* NGSPICE file created from stream_cipher.ext - technology: sky130A

* Black-box entry subcircuit for sky130_fd_sc_hd__decap_6 abstract view
.subckt sky130_fd_sc_hd__decap_6 VGND VNB VPB VPWR
.ends

* Black-box entry subcircuit for sky130_fd_sc_hd__fill_2 abstract view
.subckt sky130_fd_sc_hd__fill_2 VGND VNB VPB VPWR
.ends

* Black-box entry subcircuit for sky130_fd_sc_hd__decap_3 abstract view
.subckt sky130_fd_sc_hd__decap_3 VGND VNB VPB VPWR
.ends

* Black-box entry subcircuit for sky130_ef_sc_hd__decap_12 abstract view
.subckt sky130_ef_sc_hd__decap_12 VPWR VGND VPB VNB
.ends

* Black-box entry subcircuit for sky130_fd_sc_hd__nand2_1 abstract view
.subckt sky130_fd_sc_hd__nand2_1 A B VGND VNB VPB VPWR Y
.ends

* Black-box entry subcircuit for sky130_fd_sc_hd__a21bo_1 abstract view
.subckt sky130_fd_sc_hd__a21bo_1 A1 A2 B1_N VGND VNB VPB VPWR X
.ends

* Black-box entry subcircuit for sky130_fd_sc_hd__xnor2_1 abstract view
.subckt sky130_fd_sc_hd__xnor2_1 A B VGND VNB VPB VPWR Y
.ends

* Black-box entry subcircuit for sky130_fd_sc_hd__fill_1 abstract view
.subckt sky130_fd_sc_hd__fill_1 VGND VNB VPB VPWR
.ends

* Black-box entry subcircuit for sky130_fd_sc_hd__tapvpwrvgnd_1 abstract view
.subckt sky130_fd_sc_hd__tapvpwrvgnd_1 VGND VPWR
.ends

* Black-box entry subcircuit for sky130_fd_sc_hd__nand2b_1 abstract view
.subckt sky130_fd_sc_hd__nand2b_1 A_N B VGND VNB VPB VPWR Y
.ends

* Black-box entry subcircuit for sky130_fd_sc_hd__dfrtp_1 abstract view
.subckt sky130_fd_sc_hd__dfrtp_1 CLK D RESET_B VGND VNB VPB VPWR Q
.ends

* Black-box entry subcircuit for sky130_fd_sc_hd__decap_4 abstract view
.subckt sky130_fd_sc_hd__decap_4 VGND VNB VPB VPWR
.ends

* Black-box entry subcircuit for sky130_fd_sc_hd__decap_8 abstract view
.subckt sky130_fd_sc_hd__decap_8 VGND VNB VPB VPWR
.ends

* Black-box entry subcircuit for sky130_fd_sc_hd__a2bb2o_1 abstract view
.subckt sky130_fd_sc_hd__a2bb2o_1 A1_N A2_N B1 B2 VGND VNB VPB VPWR X
.ends

* Black-box entry subcircuit for sky130_fd_sc_hd__a21o_1 abstract view
.subckt sky130_fd_sc_hd__a21o_1 A1 A2 B1 VGND VNB VPB VPWR X
.ends

* Black-box entry subcircuit for sky130_fd_sc_hd__and2_1 abstract view
.subckt sky130_fd_sc_hd__and2_1 A B VGND VNB VPB VPWR X
.ends

* Black-box entry subcircuit for sky130_fd_sc_hd__a21oi_1 abstract view
.subckt sky130_fd_sc_hd__a21oi_1 A1 A2 B1 VGND VNB VPB VPWR Y
.ends

* Black-box entry subcircuit for sky130_fd_sc_hd__a22o_1 abstract view
.subckt sky130_fd_sc_hd__a22o_1 A1 A2 B1 B2 VGND VNB VPB VPWR X
.ends

* Black-box entry subcircuit for sky130_fd_sc_hd__buf_2 abstract view
.subckt sky130_fd_sc_hd__buf_2 A VGND VNB VPB VPWR X
.ends

* Black-box entry subcircuit for sky130_fd_sc_hd__clkbuf_4 abstract view
.subckt sky130_fd_sc_hd__clkbuf_4 A VGND VNB VPB VPWR X
.ends

* Black-box entry subcircuit for sky130_fd_sc_hd__clkbuf_2 abstract view
.subckt sky130_fd_sc_hd__clkbuf_2 A VGND VNB VPB VPWR X
.ends

* Black-box entry subcircuit for sky130_fd_sc_hd__a32o_1 abstract view
.subckt sky130_fd_sc_hd__a32o_1 A1 A2 A3 B1 B2 VGND VNB VPB VPWR X
.ends

* Black-box entry subcircuit for sky130_fd_sc_hd__o31a_1 abstract view
.subckt sky130_fd_sc_hd__o31a_1 A1 A2 A3 B1 VGND VNB VPB VPWR X
.ends

* Black-box entry subcircuit for sky130_fd_sc_hd__o21ba_1 abstract view
.subckt sky130_fd_sc_hd__o21ba_1 A1 A2 B1_N VGND VNB VPB VPWR X
.ends

* Black-box entry subcircuit for sky130_fd_sc_hd__dlygate4sd3_1 abstract view
.subckt sky130_fd_sc_hd__dlygate4sd3_1 A VGND VNB VPB VPWR X
.ends

* Black-box entry subcircuit for sky130_fd_sc_hd__nor2_1 abstract view
.subckt sky130_fd_sc_hd__nor2_1 A B VGND VNB VPB VPWR Y
.ends

* Black-box entry subcircuit for sky130_fd_sc_hd__mux2_1 abstract view
.subckt sky130_fd_sc_hd__mux2_1 A0 A1 S VGND VNB VPB VPWR X
.ends

* Black-box entry subcircuit for sky130_fd_sc_hd__or4_4 abstract view
.subckt sky130_fd_sc_hd__or4_4 A B C D VGND VNB VPB VPWR X
.ends

* Black-box entry subcircuit for sky130_fd_sc_hd__or2_1 abstract view
.subckt sky130_fd_sc_hd__or2_1 A B VGND VNB VPB VPWR X
.ends

* Black-box entry subcircuit for sky130_fd_sc_hd__xor2_1 abstract view
.subckt sky130_fd_sc_hd__xor2_1 A B VGND VNB VPB VPWR X
.ends

* Black-box entry subcircuit for sky130_fd_sc_hd__xnor2_4 abstract view
.subckt sky130_fd_sc_hd__xnor2_4 A B VGND VNB VPB VPWR Y
.ends

* Black-box entry subcircuit for sky130_fd_sc_hd__a21boi_2 abstract view
.subckt sky130_fd_sc_hd__a21boi_2 A1 A2 B1_N VGND VNB VPB VPWR Y
.ends

* Black-box entry subcircuit for sky130_fd_sc_hd__and2_2 abstract view
.subckt sky130_fd_sc_hd__and2_2 A B VGND VNB VPB VPWR X
.ends

* Black-box entry subcircuit for sky130_fd_sc_hd__o311a_1 abstract view
.subckt sky130_fd_sc_hd__o311a_1 A1 A2 A3 B1 C1 VGND VNB VPB VPWR X
.ends

* Black-box entry subcircuit for sky130_fd_sc_hd__xor2_2 abstract view
.subckt sky130_fd_sc_hd__xor2_2 A B VGND VNB VPB VPWR X
.ends

* Black-box entry subcircuit for sky130_fd_sc_hd__inv_2 abstract view
.subckt sky130_fd_sc_hd__inv_2 A VGND VNB VPB VPWR Y
.ends

* Black-box entry subcircuit for sky130_fd_sc_hd__xnor2_2 abstract view
.subckt sky130_fd_sc_hd__xnor2_2 A B VGND VNB VPB VPWR Y
.ends

* Black-box entry subcircuit for sky130_fd_sc_hd__a21oi_2 abstract view
.subckt sky130_fd_sc_hd__a21oi_2 A1 A2 B1 VGND VNB VPB VPWR Y
.ends

* Black-box entry subcircuit for sky130_fd_sc_hd__dfrtp_2 abstract view
.subckt sky130_fd_sc_hd__dfrtp_2 CLK D RESET_B VGND VNB VPB VPWR Q
.ends

* Black-box entry subcircuit for sky130_fd_sc_hd__a211o_1 abstract view
.subckt sky130_fd_sc_hd__a211o_1 A1 A2 B1 C1 VGND VNB VPB VPWR X
.ends

* Black-box entry subcircuit for sky130_fd_sc_hd__and2b_1 abstract view
.subckt sky130_fd_sc_hd__and2b_1 A_N B VGND VNB VPB VPWR X
.ends

* Black-box entry subcircuit for sky130_fd_sc_hd__mux4_1 abstract view
.subckt sky130_fd_sc_hd__mux4_1 A0 A1 A2 A3 S0 S1 VGND VNB VPB VPWR X
.ends

* Black-box entry subcircuit for sky130_fd_sc_hd__dfrtp_4 abstract view
.subckt sky130_fd_sc_hd__dfrtp_4 CLK D RESET_B VGND VNB VPB VPWR Q
.ends

* Black-box entry subcircuit for sky130_fd_sc_hd__clkbuf_16 abstract view
.subckt sky130_fd_sc_hd__clkbuf_16 A VGND VNB VPB VPWR X
.ends

* Black-box entry subcircuit for sky130_fd_sc_hd__a31o_1 abstract view
.subckt sky130_fd_sc_hd__a31o_1 A1 A2 A3 B1 VGND VNB VPB VPWR X
.ends

* Black-box entry subcircuit for sky130_fd_sc_hd__o211a_1 abstract view
.subckt sky130_fd_sc_hd__o211a_1 A1 A2 B1 C1 VGND VNB VPB VPWR X
.ends

* Black-box entry subcircuit for sky130_fd_sc_hd__or3_1 abstract view
.subckt sky130_fd_sc_hd__or3_1 A B C VGND VNB VPB VPWR X
.ends

* Black-box entry subcircuit for sky130_fd_sc_hd__nand2b_2 abstract view
.subckt sky130_fd_sc_hd__nand2b_2 A_N B VGND VNB VPB VPWR Y
.ends

* Black-box entry subcircuit for sky130_fd_sc_hd__o21ai_1 abstract view
.subckt sky130_fd_sc_hd__o21ai_1 A1 A2 B1 VGND VNB VPB VPWR Y
.ends

* Black-box entry subcircuit for sky130_fd_sc_hd__and3_1 abstract view
.subckt sky130_fd_sc_hd__and3_1 A B C VGND VNB VPB VPWR X
.ends

* Black-box entry subcircuit for sky130_fd_sc_hd__clkbuf_8 abstract view
.subckt sky130_fd_sc_hd__clkbuf_8 A VGND VNB VPB VPWR X
.ends

* Black-box entry subcircuit for sky130_fd_sc_hd__or4_1 abstract view
.subckt sky130_fd_sc_hd__or4_1 A B C D VGND VNB VPB VPWR X
.ends

* Black-box entry subcircuit for sky130_fd_sc_hd__buf_4 abstract view
.subckt sky130_fd_sc_hd__buf_4 A VGND VNB VPB VPWR X
.ends

* Black-box entry subcircuit for sky130_fd_sc_hd__o31ai_2 abstract view
.subckt sky130_fd_sc_hd__o31ai_2 A1 A2 A3 B1 VGND VNB VPB VPWR Y
.ends

* Black-box entry subcircuit for sky130_fd_sc_hd__a221o_1 abstract view
.subckt sky130_fd_sc_hd__a221o_1 A1 A2 B1 B2 C1 VGND VNB VPB VPWR X
.ends

* Black-box entry subcircuit for sky130_fd_sc_hd__clkbuf_1 abstract view
.subckt sky130_fd_sc_hd__clkbuf_1 A VGND VNB VPB VPWR X
.ends

* Black-box entry subcircuit for sky130_fd_sc_hd__nor3_1 abstract view
.subckt sky130_fd_sc_hd__nor3_1 A B C VGND VNB VPB VPWR Y
.ends

* Black-box entry subcircuit for sky130_fd_sc_hd__nand4_1 abstract view
.subckt sky130_fd_sc_hd__nand4_1 A B C D VGND VNB VPB VPWR Y
.ends

* Black-box entry subcircuit for sky130_fd_sc_hd__dfstp_1 abstract view
.subckt sky130_fd_sc_hd__dfstp_1 CLK D SET_B VGND VNB VPB VPWR Q
.ends

* Black-box entry subcircuit for sky130_fd_sc_hd__nand3_1 abstract view
.subckt sky130_fd_sc_hd__nand3_1 A B C VGND VNB VPB VPWR Y
.ends

* Black-box entry subcircuit for sky130_fd_sc_hd__nand2b_4 abstract view
.subckt sky130_fd_sc_hd__nand2b_4 A_N B VGND VNB VPB VPWR Y
.ends

* Black-box entry subcircuit for sky130_fd_sc_hd__inv_6 abstract view
.subckt sky130_fd_sc_hd__inv_6 A VGND VNB VPB VPWR Y
.ends

* Black-box entry subcircuit for sky130_fd_sc_hd__nand2_2 abstract view
.subckt sky130_fd_sc_hd__nand2_2 A B VGND VNB VPB VPWR Y
.ends

* Black-box entry subcircuit for sky130_fd_sc_hd__clkinv_2 abstract view
.subckt sky130_fd_sc_hd__clkinv_2 A VGND VNB VPB VPWR Y
.ends

* Black-box entry subcircuit for sky130_fd_sc_hd__o22a_1 abstract view
.subckt sky130_fd_sc_hd__o22a_1 A1 A2 B1 B2 VGND VNB VPB VPWR X
.ends

* Black-box entry subcircuit for sky130_fd_sc_hd__and4b_1 abstract view
.subckt sky130_fd_sc_hd__and4b_1 A_N B C D VGND VNB VPB VPWR X
.ends

* Black-box entry subcircuit for sky130_fd_sc_hd__nand3b_1 abstract view
.subckt sky130_fd_sc_hd__nand3b_1 A_N B C VGND VNB VPB VPWR Y
.ends

* Black-box entry subcircuit for sky130_fd_sc_hd__o21a_1 abstract view
.subckt sky130_fd_sc_hd__o21a_1 A1 A2 B1 VGND VNB VPB VPWR X
.ends

* Black-box entry subcircuit for sky130_fd_sc_hd__bufinv_16 abstract view
.subckt sky130_fd_sc_hd__bufinv_16 A VGND VNB VPB VPWR Y
.ends

* Black-box entry subcircuit for sky130_fd_sc_hd__inv_8 abstract view
.subckt sky130_fd_sc_hd__inv_8 A VGND VNB VPB VPWR Y
.ends

* Black-box entry subcircuit for sky130_fd_sc_hd__a21boi_1 abstract view
.subckt sky130_fd_sc_hd__a21boi_1 A1 A2 B1_N VGND VNB VPB VPWR Y
.ends

* Black-box entry subcircuit for sky130_fd_sc_hd__o221a_1 abstract view
.subckt sky130_fd_sc_hd__o221a_1 A1 A2 B1 B2 C1 VGND VNB VPB VPWR X
.ends

* Black-box entry subcircuit for sky130_fd_sc_hd__nor2_2 abstract view
.subckt sky130_fd_sc_hd__nor2_2 A B VGND VNB VPB VPWR Y
.ends

* Black-box entry subcircuit for sky130_fd_sc_hd__mux4_2 abstract view
.subckt sky130_fd_sc_hd__mux4_2 A0 A1 A2 A3 S0 S1 VGND VNB VPB VPWR X
.ends

* Black-box entry subcircuit for sky130_fd_sc_hd__a21oi_4 abstract view
.subckt sky130_fd_sc_hd__a21oi_4 A1 A2 B1 VGND VNB VPB VPWR Y
.ends

* Black-box entry subcircuit for sky130_fd_sc_hd__or4b_1 abstract view
.subckt sky130_fd_sc_hd__or4b_1 A B C D_N VGND VNB VPB VPWR X
.ends

* Black-box entry subcircuit for sky130_fd_sc_hd__a31oi_4 abstract view
.subckt sky130_fd_sc_hd__a31oi_4 A1 A2 A3 B1 VGND VNB VPB VPWR Y
.ends

* Black-box entry subcircuit for sky130_fd_sc_hd__clkinvlp_4 abstract view
.subckt sky130_fd_sc_hd__clkinvlp_4 A VGND VNB VPB VPWR Y
.ends

* Black-box entry subcircuit for sky130_fd_sc_hd__or4b_4 abstract view
.subckt sky130_fd_sc_hd__or4b_4 A B C D_N VGND VNB VPB VPWR X
.ends

* Black-box entry subcircuit for sky130_fd_sc_hd__and3b_4 abstract view
.subckt sky130_fd_sc_hd__and3b_4 A_N B C VGND VNB VPB VPWR X
.ends

* Black-box entry subcircuit for sky130_fd_sc_hd__o2111a_1 abstract view
.subckt sky130_fd_sc_hd__o2111a_1 A1 A2 B1 C1 D1 VGND VNB VPB VPWR X
.ends

* Black-box entry subcircuit for sky130_fd_sc_hd__clkinv_8 abstract view
.subckt sky130_fd_sc_hd__clkinv_8 A VGND VNB VPB VPWR Y
.ends

* Black-box entry subcircuit for sky130_fd_sc_hd__and4_1 abstract view
.subckt sky130_fd_sc_hd__and4_1 A B C D VGND VNB VPB VPWR X
.ends

* Black-box entry subcircuit for sky130_fd_sc_hd__xor2_4 abstract view
.subckt sky130_fd_sc_hd__xor2_4 A B VGND VNB VPB VPWR X
.ends

* Black-box entry subcircuit for sky130_fd_sc_hd__and3b_1 abstract view
.subckt sky130_fd_sc_hd__and3b_1 A_N B C VGND VNB VPB VPWR X
.ends

* Black-box entry subcircuit for sky130_fd_sc_hd__a311o_1 abstract view
.subckt sky130_fd_sc_hd__a311o_1 A1 A2 A3 B1 C1 VGND VNB VPB VPWR X
.ends

* Black-box entry subcircuit for sky130_fd_sc_hd__conb_1 abstract view
.subckt sky130_fd_sc_hd__conb_1 VGND VNB VPB VPWR HI LO
.ends

* Black-box entry subcircuit for sky130_fd_sc_hd__and4b_4 abstract view
.subckt sky130_fd_sc_hd__and4b_4 A_N B C D VGND VNB VPB VPWR X
.ends

* Black-box entry subcircuit for sky130_fd_sc_hd__clkinv_4 abstract view
.subckt sky130_fd_sc_hd__clkinv_4 A VGND VNB VPB VPWR Y
.ends

* Black-box entry subcircuit for sky130_fd_sc_hd__and4bb_4 abstract view
.subckt sky130_fd_sc_hd__and4bb_4 A_N B_N C D VGND VNB VPB VPWR X
.ends

* Black-box entry subcircuit for sky130_fd_sc_hd__nor2_4 abstract view
.subckt sky130_fd_sc_hd__nor2_4 A B VGND VNB VPB VPWR Y
.ends

* Black-box entry subcircuit for sky130_fd_sc_hd__o21ai_2 abstract view
.subckt sky130_fd_sc_hd__o21ai_2 A1 A2 B1 VGND VNB VPB VPWR Y
.ends

* Black-box entry subcircuit for sky130_fd_sc_hd__a31oi_2 abstract view
.subckt sky130_fd_sc_hd__a31oi_2 A1 A2 A3 B1 VGND VNB VPB VPWR Y
.ends

* Black-box entry subcircuit for sky130_fd_sc_hd__a21o_2 abstract view
.subckt sky130_fd_sc_hd__a21o_2 A1 A2 B1 VGND VNB VPB VPWR X
.ends

* Black-box entry subcircuit for sky130_fd_sc_hd__or2_2 abstract view
.subckt sky130_fd_sc_hd__or2_2 A B VGND VNB VPB VPWR X
.ends

* Black-box entry subcircuit for sky130_fd_sc_hd__nand3_2 abstract view
.subckt sky130_fd_sc_hd__nand3_2 A B C VGND VNB VPB VPWR Y
.ends

* Black-box entry subcircuit for sky130_fd_sc_hd__buf_1 abstract view
.subckt sky130_fd_sc_hd__buf_1 A VGND VNB VPB VPWR X
.ends

* Black-box entry subcircuit for sky130_fd_sc_hd__and3b_2 abstract view
.subckt sky130_fd_sc_hd__and3b_2 A_N B C VGND VNB VPB VPWR X
.ends

* Black-box entry subcircuit for sky130_fd_sc_hd__o221ai_4 abstract view
.subckt sky130_fd_sc_hd__o221ai_4 A1 A2 B1 B2 C1 VGND VNB VPB VPWR Y
.ends

* Black-box entry subcircuit for sky130_fd_sc_hd__o21bai_1 abstract view
.subckt sky130_fd_sc_hd__o21bai_1 A1 A2 B1_N VGND VNB VPB VPWR Y
.ends

* Black-box entry subcircuit for sky130_fd_sc_hd__or3b_1 abstract view
.subckt sky130_fd_sc_hd__or3b_1 A B C_N VGND VNB VPB VPWR X
.ends

* Black-box entry subcircuit for sky130_fd_sc_hd__o211ai_4 abstract view
.subckt sky130_fd_sc_hd__o211ai_4 A1 A2 B1 C1 VGND VNB VPB VPWR Y
.ends

* Black-box entry subcircuit for sky130_fd_sc_hd__nor3_4 abstract view
.subckt sky130_fd_sc_hd__nor3_4 A B C VGND VNB VPB VPWR Y
.ends

* Black-box entry subcircuit for sky130_fd_sc_hd__o2bb2a_1 abstract view
.subckt sky130_fd_sc_hd__o2bb2a_1 A1_N A2_N B1 B2 VGND VNB VPB VPWR X
.ends

* Black-box entry subcircuit for sky130_fd_sc_hd__a2111o_1 abstract view
.subckt sky130_fd_sc_hd__a2111o_1 A1 A2 B1 C1 D1 VGND VNB VPB VPWR X
.ends

* Black-box entry subcircuit for sky130_fd_sc_hd__o211a_2 abstract view
.subckt sky130_fd_sc_hd__o211a_2 A1 A2 B1 C1 VGND VNB VPB VPWR X
.ends

* Black-box entry subcircuit for sky130_fd_sc_hd__o41a_1 abstract view
.subckt sky130_fd_sc_hd__o41a_1 A1 A2 A3 A4 B1 VGND VNB VPB VPWR X
.ends

* Black-box entry subcircuit for sky130_fd_sc_hd__a32oi_4 abstract view
.subckt sky130_fd_sc_hd__a32oi_4 A1 A2 A3 B1 B2 VGND VNB VPB VPWR Y
.ends

* Black-box entry subcircuit for sky130_fd_sc_hd__or2_4 abstract view
.subckt sky130_fd_sc_hd__or2_4 A B VGND VNB VPB VPWR X
.ends

* Black-box entry subcircuit for sky130_fd_sc_hd__nor3b_1 abstract view
.subckt sky130_fd_sc_hd__nor3b_1 A B C_N VGND VNB VPB VPWR Y
.ends

* Black-box entry subcircuit for sky130_fd_sc_hd__a211o_2 abstract view
.subckt sky130_fd_sc_hd__a211o_2 A1 A2 B1 C1 VGND VNB VPB VPWR X
.ends

* Black-box entry subcircuit for sky130_fd_sc_hd__o31ai_1 abstract view
.subckt sky130_fd_sc_hd__o31ai_1 A1 A2 A3 B1 VGND VNB VPB VPWR Y
.ends

* Black-box entry subcircuit for sky130_fd_sc_hd__or4bb_1 abstract view
.subckt sky130_fd_sc_hd__or4bb_1 A B C_N D_N VGND VNB VPB VPWR X
.ends

* Black-box entry subcircuit for sky130_fd_sc_hd__o22ai_2 abstract view
.subckt sky130_fd_sc_hd__o22ai_2 A1 A2 B1 B2 VGND VNB VPB VPWR Y
.ends

* Black-box entry subcircuit for sky130_fd_sc_hd__a211oi_1 abstract view
.subckt sky130_fd_sc_hd__a211oi_1 A1 A2 B1 C1 VGND VNB VPB VPWR Y
.ends

* Black-box entry subcircuit for sky130_fd_sc_hd__a211oi_2 abstract view
.subckt sky130_fd_sc_hd__a211oi_2 A1 A2 B1 C1 VGND VNB VPB VPWR Y
.ends

* Black-box entry subcircuit for sky130_fd_sc_hd__o211ai_2 abstract view
.subckt sky130_fd_sc_hd__o211ai_2 A1 A2 B1 C1 VGND VNB VPB VPWR Y
.ends

* Black-box entry subcircuit for sky130_fd_sc_hd__nor3_2 abstract view
.subckt sky130_fd_sc_hd__nor3_2 A B C VGND VNB VPB VPWR Y
.ends

* Black-box entry subcircuit for sky130_fd_sc_hd__o311a_2 abstract view
.subckt sky130_fd_sc_hd__o311a_2 A1 A2 A3 B1 C1 VGND VNB VPB VPWR X
.ends

* Black-box entry subcircuit for sky130_fd_sc_hd__o32ai_1 abstract view
.subckt sky130_fd_sc_hd__o32ai_1 A1 A2 A3 B1 B2 VGND VNB VPB VPWR Y
.ends

* Black-box entry subcircuit for sky130_fd_sc_hd__or4b_2 abstract view
.subckt sky130_fd_sc_hd__or4b_2 A B C D_N VGND VNB VPB VPWR X
.ends

* Black-box entry subcircuit for sky130_fd_sc_hd__diode_2 abstract view
.subckt sky130_fd_sc_hd__diode_2 DIODE VGND VNB VPB VPWR
.ends

* Black-box entry subcircuit for sky130_fd_sc_hd__o2bb2ai_1 abstract view
.subckt sky130_fd_sc_hd__o2bb2ai_1 A1_N A2_N B1 B2 VGND VNB VPB VPWR Y
.ends

* Black-box entry subcircuit for sky130_fd_sc_hd__and4_4 abstract view
.subckt sky130_fd_sc_hd__and4_4 A B C D VGND VNB VPB VPWR X
.ends

* Black-box entry subcircuit for sky130_fd_sc_hd__a31oi_1 abstract view
.subckt sky130_fd_sc_hd__a31oi_1 A1 A2 A3 B1 VGND VNB VPB VPWR Y
.ends

* Black-box entry subcircuit for sky130_fd_sc_hd__nand2_8 abstract view
.subckt sky130_fd_sc_hd__nand2_8 A B VGND VNB VPB VPWR Y
.ends

.subckt stream_cipher VGND VPWR clk ena rst_n ui_in[0] ui_in[1] ui_in[2] ui_in[3]
+ ui_in[4] ui_in[5] ui_in[6] ui_in[7] uio_in[0] uio_in[1] uio_in[2] uio_in[3] uio_in[4]
+ uio_in[5] uio_in[6] uio_in[7] uio_oe[0] uio_oe[1] uio_oe[2] uio_oe[3] uio_oe[4]
+ uio_oe[5] uio_oe[6] uio_oe[7] uio_out[0] uio_out[1] uio_out[2] uio_out[3] uio_out[4]
+ uio_out[5] uio_out[6] uio_out[7] uo_out[0] uo_out[1] uo_out[2] uo_out[3] uo_out[4]
+ uo_out[5] uo_out[6] uo_out[7]
XFILLER_67_553 VGND VGND VPWR VPWR sky130_fd_sc_hd__decap_6
XFILLER_39_244 VGND VGND VPWR VPWR sky130_fd_sc_hd__fill_2
XFILLER_94_361 VGND VGND VPWR VPWR sky130_fd_sc_hd__decap_3
XFILLER_82_501 VPWR VGND VPWR VGND sky130_ef_sc_hd__decap_12
X_3155_ _4762_/Q _3156_/B VGND VGND VPWR VPWR _3179_/A sky130_fd_sc_hd__nand2_1
XFILLER_39_277 VGND VGND VPWR VPWR sky130_fd_sc_hd__decap_3
XFILLER_82_545 VPWR VGND VPWR VGND sky130_ef_sc_hd__decap_12
X_3086_ _3060_/B _3064_/B _3060_/A VGND VGND VPWR VPWR _3087_/B sky130_fd_sc_hd__a21bo_1
XFILLER_67_597 VPWR VGND VPWR VGND sky130_ef_sc_hd__decap_12
XFILLER_82_589 VPWR VGND VPWR VGND sky130_ef_sc_hd__decap_12
XFILLER_52_29 VPWR VGND VPWR VGND sky130_ef_sc_hd__decap_12
X_3988_ _3988_/A _3988_/B VGND VGND VPWR VPWR _3989_/B sky130_fd_sc_hd__xnor2_1
XFILLER_50_475 VGND VGND VPWR VPWR sky130_fd_sc_hd__fill_1
XTAP_TAPCELL_ROW_79_1100 VGND VPWR sky130_fd_sc_hd__tapvpwrvgnd_1
X_2939_ _2937_/Y _2939_/B VGND VGND VPWR VPWR _2963_/B sky130_fd_sc_hd__nand2b_1
X_4609_ _4756_/CLK _4609_/D fanout134/X VGND VGND VPWR VPWR _4609_/Q sky130_fd_sc_hd__dfrtp_1
XFILLER_89_111 VGND VGND VPWR VPWR sky130_fd_sc_hd__fill_1
XFILLER_104_433 VPWR VGND VPWR VGND sky130_ef_sc_hd__decap_12
XFILLER_77_15 VPWR VGND VPWR VGND sky130_ef_sc_hd__decap_12
XFILLER_104_477 VPWR VGND VPWR VGND sky130_ef_sc_hd__decap_12
XFILLER_58_531 VGND VGND VPWR VPWR sky130_fd_sc_hd__fill_1
XFILLER_93_69 VPWR VGND VPWR VGND sky130_ef_sc_hd__decap_12
XFILLER_26_41 VPWR VGND VPWR VGND sky130_ef_sc_hd__decap_12
XFILLER_33_409 VGND VGND VPWR VPWR sky130_fd_sc_hd__decap_3
XFILLER_13_111 VGND VGND VPWR VPWR sky130_fd_sc_hd__fill_1
XTAP_TAPCELL_ROW_11_356 VGND VPWR sky130_fd_sc_hd__tapvpwrvgnd_1
XFILLER_5_321 VGND VGND VPWR VPWR sky130_fd_sc_hd__fill_2
XTAP_TAPCELL_ROW_97_1299 VGND VPWR sky130_fd_sc_hd__tapvpwrvgnd_1
XFILLER_107_293 VPWR VGND VPWR VGND sky130_ef_sc_hd__decap_12
XFILLER_95_125 VPWR VGND VPWR VGND sky130_ef_sc_hd__decap_12
XFILLER_95_169 VPWR VGND VPWR VGND sky130_ef_sc_hd__decap_12
XFILLER_64_501 VPWR VGND VPWR VGND sky130_ef_sc_hd__decap_12
XFILLER_76_383 VGND VGND VPWR VPWR sky130_fd_sc_hd__decap_6
XFILLER_36_214 VPWR VGND VPWR VGND sky130_ef_sc_hd__decap_12
XFILLER_64_545 VPWR VGND VPWR VGND sky130_ef_sc_hd__decap_12
XTAP_TAPCELL_ROW_19_445 VGND VPWR sky130_fd_sc_hd__tapvpwrvgnd_1
XFILLER_36_247 VGND VGND VPWR VPWR sky130_fd_sc_hd__decap_4
XFILLER_36_258 VGND VGND VPWR VPWR sky130_fd_sc_hd__decap_8
XTAP_TAPCELL_ROW_47_754 VGND VPWR sky130_fd_sc_hd__tapvpwrvgnd_1
XFILLER_64_589 VPWR VGND VPWR VGND sky130_ef_sc_hd__decap_12
XFILLER_51_228 VPWR VGND VPWR VGND sky130_ef_sc_hd__decap_12
XTAP_TAPCELL_ROW_106_1395 VGND VPWR sky130_fd_sc_hd__tapvpwrvgnd_1
X_3911_ _3909_/Y _3910_/X _4549_/Q _3979_/B2 VGND VGND VPWR VPWR _4549_/D sky130_fd_sc_hd__a2bb2o_1
X_3842_ _4545_/Q _3810_/B _3841_/X VGND VGND VPWR VPWR _3843_/D sky130_fd_sc_hd__a21o_1
XFILLER_32_453 VGND VGND VPWR VPWR sky130_fd_sc_hd__decap_3
X_3773_ _3774_/A _3774_/B VGND VGND VPWR VPWR _3820_/A sky130_fd_sc_hd__and2_1
X_2724_ _2680_/B _2700_/B _2698_/X VGND VGND VPWR VPWR _2724_/Y sky130_fd_sc_hd__a21oi_1
X_2655_ _4532_/Q _4523_/Q VGND VGND VPWR VPWR _2658_/C sky130_fd_sc_hd__nand2_1
XTAP_TAPCELL_ROW_74_1041 VGND VPWR sky130_fd_sc_hd__tapvpwrvgnd_1
X_2586_ _4491_/Q _2587_/B VGND VGND VPWR VPWR _2586_/X sky130_fd_sc_hd__and2_1
X_4325_ _3278_/B _4331_/A2 _3287_/A _4331_/B2 VGND VGND VPWR VPWR _4737_/D sky130_fd_sc_hd__a22o_1
XFILLER_99_497 VGND VGND VPWR VPWR sky130_fd_sc_hd__decap_6
XFILLER_87_615 VGND VGND VPWR VPWR sky130_fd_sc_hd__fill_1
Xfanout105 hold14/A VGND VGND VPWR VPWR _3836_/A sky130_fd_sc_hd__buf_2
Xfanout138 fanout139/X VGND VGND VPWR VPWR fanout138/X sky130_fd_sc_hd__clkbuf_4
Xfanout127 fanout128/X VGND VGND VPWR VPWR fanout127/X sky130_fd_sc_hd__clkbuf_4
Xfanout116 _4362_/Q VGND VGND VPWR VPWR _4131_/B sky130_fd_sc_hd__buf_2
XFILLER_101_447 VGND VGND VPWR VPWR sky130_fd_sc_hd__fill_1
Xfanout149 fanout151/X VGND VGND VPWR VPWR fanout149/X sky130_fd_sc_hd__clkbuf_2
X_4256_ _4256_/A1 _4253_/X _4255_/Y _4262_/A hold264/X VGND VGND VPWR VPWR _4713_/D
+ sky130_fd_sc_hd__a32o_1
X_3207_ _4518_/Q _3207_/B VGND VGND VPWR VPWR _3209_/A sky130_fd_sc_hd__xnor2_1
XFILLER_74_309 VGND VGND VPWR VPWR sky130_fd_sc_hd__fill_1
X_4187_ _4694_/Q _4187_/B VGND VGND VPWR VPWR _4194_/C sky130_fd_sc_hd__and2_1
X_3138_ _3122_/A _3120_/B _3122_/B _3118_/Y VGND VGND VPWR VPWR _3145_/A sky130_fd_sc_hd__o31a_1
XFILLER_27_225 VGND VGND VPWR VPWR sky130_fd_sc_hd__fill_2
XFILLER_55_523 VPWR VGND VPWR VGND sky130_ef_sc_hd__decap_12
XFILLER_103_57 VPWR VGND VPWR VGND sky130_ef_sc_hd__decap_12
XFILLER_63_39 VPWR VGND VPWR VGND sky130_ef_sc_hd__decap_12
X_3069_ _3021_/A _3046_/A _3046_/B VGND VGND VPWR VPWR _3069_/X sky130_fd_sc_hd__o21ba_1
XFILLER_27_269 VGND VGND VPWR VPWR sky130_fd_sc_hd__decap_8
XTAP_TAPCELL_ROW_85_1170 VGND VPWR sky130_fd_sc_hd__tapvpwrvgnd_1
XFILLER_12_65 VPWR VGND VPWR VGND sky130_ef_sc_hd__decap_12
Xhold170 _4666_/Q VGND VGND VPWR VPWR hold170/X sky130_fd_sc_hd__dlygate4sd3_1
XFILLER_77_103 VGND VGND VPWR VPWR sky130_fd_sc_hd__fill_1
Xhold192 _4489_/Q VGND VGND VPWR VPWR hold192/X sky130_fd_sc_hd__dlygate4sd3_1
Xhold181 _4427_/Q VGND VGND VPWR VPWR hold181/X sky130_fd_sc_hd__dlygate4sd3_1
XFILLER_93_629 VGND VGND VPWR VPWR sky130_fd_sc_hd__decap_8
XFILLER_77_169 VGND VGND VPWR VPWR sky130_fd_sc_hd__decap_3
XFILLER_92_139 VGND VGND VPWR VPWR sky130_fd_sc_hd__fill_1
XFILLER_37_51 VGND VGND VPWR VPWR sky130_fd_sc_hd__decap_4
XFILLER_58_394 VPWR VGND VPWR VGND sky130_ef_sc_hd__decap_12
XTAP_TAPCELL_ROW_16_404 VGND VPWR sky130_fd_sc_hd__tapvpwrvgnd_1
XFILLER_18_269 VGND VGND VPWR VPWR sky130_fd_sc_hd__fill_1
XTAP_TAPCELL_ROW_44_713 VGND VPWR sky130_fd_sc_hd__tapvpwrvgnd_1
XFILLER_46_589 VGND VGND VPWR VPWR sky130_fd_sc_hd__fill_1
XFILLER_61_559 VGND VGND VPWR VPWR sky130_fd_sc_hd__fill_1
XTAP_TAPCELL_ROW_99_1317 VGND VPWR sky130_fd_sc_hd__tapvpwrvgnd_1
XFILLER_53_83 VGND VGND VPWR VPWR sky130_fd_sc_hd__decap_3
XTAP_TAPCELL_ROW_24_492 VGND VPWR sky130_fd_sc_hd__tapvpwrvgnd_1
X_2440_ _2442_/A _2442_/B VGND VGND VPWR VPWR _2445_/B sky130_fd_sc_hd__nor2_1
XFILLER_96_401 VPWR VGND VPWR VGND sky130_ef_sc_hd__decap_12
XFILLER_69_615 VGND VGND VPWR VPWR sky130_fd_sc_hd__fill_1
X_2371_ hold55/X _2379_/A2 _2379_/B1 _4536_/Q VGND VGND VPWR VPWR _4386_/D sky130_fd_sc_hd__a22o_1
XFILLER_96_445 VPWR VGND VPWR VGND sky130_ef_sc_hd__decap_12
X_4110_ hold150/X _4026_/X _4112_/S VGND VGND VPWR VPWR _4642_/D sky130_fd_sc_hd__mux2_1
XFILLER_96_489 VPWR VGND VPWR VGND sky130_ef_sc_hd__decap_12
XFILLER_1_390 VGND VGND VPWR VPWR sky130_fd_sc_hd__fill_2
X_4041_ _4041_/A _4068_/B _4131_/B _4068_/D VGND VGND VPWR VPWR _4049_/S sky130_fd_sc_hd__or4_4
XFILLER_56_309 VGND VGND VPWR VPWR sky130_fd_sc_hd__fill_1
XFILLER_76_191 VGND VGND VPWR VPWR sky130_fd_sc_hd__decap_4
XFILLER_52_548 VPWR VGND VPWR VGND sky130_ef_sc_hd__decap_12
XFILLER_60_581 VGND VGND VPWR VPWR sky130_fd_sc_hd__decap_6
XFILLER_20_401 VPWR VGND VPWR VGND sky130_ef_sc_hd__decap_12
X_3825_ _3826_/A _3826_/B VGND VGND VPWR VPWR _3862_/A sky130_fd_sc_hd__or2_1
XFILLER_20_434 VGND VGND VPWR VPWR sky130_fd_sc_hd__fill_2
XFILLER_20_456 VPWR VGND VPWR VGND sky130_ef_sc_hd__decap_12
X_3756_ _4757_/Q _3756_/B VGND VGND VPWR VPWR _3759_/A sky130_fd_sc_hd__xor2_1
X_2707_ _2707_/A _2707_/B VGND VGND VPWR VPWR _3495_/A sky130_fd_sc_hd__xnor2_4
X_3687_ _3687_/A _3687_/B VGND VGND VPWR VPWR _3693_/A sky130_fd_sc_hd__nor2_1
X_2638_ _2612_/A _2611_/B _2611_/A VGND VGND VPWR VPWR _2639_/B sky130_fd_sc_hd__a21boi_2
XFILLER_99_261 VPWR VGND VPWR VGND sky130_ef_sc_hd__decap_12
X_2569_ _3278_/A _2569_/B VGND VGND VPWR VPWR _2570_/B sky130_fd_sc_hd__or2_1
XFILLER_87_434 VPWR VGND VPWR VGND sky130_ef_sc_hd__decap_12
X_4308_ _4487_/Q _4308_/B VGND VGND VPWR VPWR _4308_/Y sky130_fd_sc_hd__xnor2_1
XFILLER_75_629 VGND VGND VPWR VPWR sky130_fd_sc_hd__decap_8
X_4239_ _4709_/Q _4239_/B VGND VGND VPWR VPWR _4239_/X sky130_fd_sc_hd__or2_1
XFILLER_74_139 VGND VGND VPWR VPWR sky130_fd_sc_hd__fill_1
XFILLER_74_27 VGND VGND VPWR VPWR sky130_fd_sc_hd__fill_1
XFILLER_28_545 VGND VGND VPWR VPWR sky130_fd_sc_hd__decap_6
XFILLER_82_183 VGND VGND VPWR VPWR sky130_fd_sc_hd__fill_1
XFILLER_43_559 VGND VGND VPWR VPWR sky130_fd_sc_hd__fill_1
XFILLER_90_15 VPWR VGND VPWR VGND sky130_ef_sc_hd__decap_12
XFILLER_70_356 VGND VGND VPWR VPWR sky130_fd_sc_hd__decap_8
XFILLER_30_209 VPWR VGND VPWR VGND sky130_ef_sc_hd__decap_12
XFILLER_11_445 VGND VGND VPWR VPWR sky130_fd_sc_hd__decap_3
XFILLER_7_449 VGND VGND VPWR VPWR sky130_fd_sc_hd__decap_4
XTAP_TAPCELL_ROW_21_462 VGND VPWR sky130_fd_sc_hd__tapvpwrvgnd_1
XFILLER_99_57 VPWR VGND VPWR VGND sky130_ef_sc_hd__decap_12
XTAP_TAPCELL_ROW_94_1269 VGND VPWR sky130_fd_sc_hd__tapvpwrvgnd_1
XFILLER_2_121 VGND VGND VPWR VPWR sky130_fd_sc_hd__decap_4
XFILLER_105_561 VPWR VGND VPWR VGND sky130_ef_sc_hd__decap_12
XFILLER_78_467 VGND VGND VPWR VPWR sky130_fd_sc_hd__decap_8
XFILLER_78_489 VPWR VGND VPWR VGND sky130_ef_sc_hd__decap_12
XFILLER_0_57 VPWR VGND VPWR VGND sky130_ef_sc_hd__decap_12
XTAP_TAPCELL_ROW_29_551 VGND VPWR sky130_fd_sc_hd__tapvpwrvgnd_1
XTAP_TAPCELL_ROW_57_860 VGND VPWR sky130_fd_sc_hd__tapvpwrvgnd_1
XPHY_EDGE_ROW_14_Left_122 VGND VGND VPWR VPWR sky130_fd_sc_hd__decap_3
XTAP_TAPCELL_ROW_103_1365 VGND VPWR sky130_fd_sc_hd__tapvpwrvgnd_1
XFILLER_14_261 VGND VGND VPWR VPWR sky130_fd_sc_hd__decap_3
XFILLER_42_570 VGND VGND VPWR VPWR sky130_fd_sc_hd__fill_1
XFILLER_9_55 VGND VGND VPWR VPWR sky130_fd_sc_hd__fill_1
XPHY_EDGE_ROW_104_Right_104 VGND VGND VPWR VPWR sky130_fd_sc_hd__decap_3
X_4590_ _4737_/CLK _4590_/D fanout122/X VGND VGND VPWR VPWR _4590_/Q sky130_fd_sc_hd__dfrtp_1
X_3610_ _3610_/A _3610_/B VGND VGND VPWR VPWR _3610_/Y sky130_fd_sc_hd__nand2_1
X_3541_ _3541_/A _3780_/A VGND VGND VPWR VPWR _3542_/B sky130_fd_sc_hd__xnor2_1
XPHY_EDGE_ROW_23_Left_131 VGND VGND VPWR VPWR sky130_fd_sc_hd__decap_3
X_3472_ _3543_/D _3472_/B VGND VGND VPWR VPWR _3475_/A sky130_fd_sc_hd__nor2_1
XFILLER_50_3 VPWR VGND VPWR VGND sky130_ef_sc_hd__decap_12
XTAP_TAPCELL_ROW_71_1011 VGND VPWR sky130_fd_sc_hd__tapvpwrvgnd_1
X_2423_ _4365_/Q _2423_/B VGND VGND VPWR VPWR _2427_/C sky130_fd_sc_hd__and2_1
X_2354_ _2354_/A _2423_/B VGND VGND VPWR VPWR _2356_/C sky130_fd_sc_hd__nand2_1
XFILLER_96_253 VPWR VGND VPWR VGND sky130_ef_sc_hd__decap_12
X_2285_ _4225_/A _4461_/Q VGND VGND VPWR VPWR _2285_/Y sky130_fd_sc_hd__nor2_1
XFILLER_57_629 VGND VGND VPWR VPWR sky130_fd_sc_hd__decap_8
X_4024_ _4732_/Q _4030_/B VGND VGND VPWR VPWR _4024_/X sky130_fd_sc_hd__and2_2
XFILLER_56_139 VGND VGND VPWR VPWR sky130_fd_sc_hd__fill_1
XPHY_EDGE_ROW_32_Left_140 VGND VGND VPWR VPWR sky130_fd_sc_hd__decap_3
XFILLER_37_375 VGND VGND VPWR VPWR sky130_fd_sc_hd__decap_4
XFILLER_25_559 VGND VGND VPWR VPWR sky130_fd_sc_hd__fill_1
XFILLER_37_397 VGND VGND VPWR VPWR sky130_fd_sc_hd__fill_1
XFILLER_52_334 VGND VGND VPWR VPWR sky130_fd_sc_hd__fill_1
XFILLER_52_345 VGND VGND VPWR VPWR sky130_fd_sc_hd__decap_8
XFILLER_52_389 VPWR VGND VPWR VGND sky130_ef_sc_hd__decap_12
X_3808_ _3808_/A _3808_/B VGND VGND VPWR VPWR _3809_/B sky130_fd_sc_hd__xnor2_1
XFILLER_60_29 VPWR VGND VPWR VGND sky130_ef_sc_hd__decap_12
X_3739_ _3740_/A _3740_/B _3740_/C VGND VGND VPWR VPWR _3741_/A sky130_fd_sc_hd__a21o_1
XFILLER_4_419 VGND VGND VPWR VPWR sky130_fd_sc_hd__fill_1
XFILLER_69_27 VPWR VGND VPWR VGND sky130_ef_sc_hd__decap_12
XFILLER_79_209 VGND VGND VPWR VPWR sky130_fd_sc_hd__fill_1
XFILLER_102_531 VGND VGND VPWR VPWR sky130_fd_sc_hd__fill_1
XFILLER_0_614 VGND VGND VPWR VPWR sky130_fd_sc_hd__fill_2
XFILLER_85_15 VPWR VGND VPWR VGND sky130_ef_sc_hd__decap_12
XFILLER_18_53 VPWR VGND VPWR VGND sky130_ef_sc_hd__decap_12
XFILLER_90_418 VGND VGND VPWR VPWR sky130_fd_sc_hd__fill_2
XFILLER_28_353 VGND VGND VPWR VPWR sky130_fd_sc_hd__fill_2
XFILLER_18_97 VGND VGND VPWR VPWR sky130_fd_sc_hd__fill_1
XTAP_TAPCELL_ROW_26_521 VGND VPWR sky130_fd_sc_hd__tapvpwrvgnd_1
XTAP_TAPCELL_ROW_54_830 VGND VPWR sky130_fd_sc_hd__tapvpwrvgnd_1
XFILLER_55_183 VGND VGND VPWR VPWR sky130_fd_sc_hd__decap_3
XFILLER_31_529 VPWR VGND VPWR VGND sky130_ef_sc_hd__decap_12
XFILLER_34_41 VPWR VGND VPWR VGND sky130_ef_sc_hd__decap_12
XFILLER_70_197 VGND VGND VPWR VPWR sky130_fd_sc_hd__decap_8
XFILLER_105_391 VGND VGND VPWR VPWR sky130_fd_sc_hd__fill_1
XFILLER_66_404 VPWR VGND VPWR VGND sky130_ef_sc_hd__decap_12
XFILLER_93_278 VGND VGND VPWR VPWR sky130_fd_sc_hd__fill_2
XFILLER_75_81 VGND VGND VPWR VPWR sky130_fd_sc_hd__decap_6
XFILLER_46_150 VGND VGND VPWR VPWR sky130_fd_sc_hd__decap_3
XFILLER_98_3 VPWR VGND VPWR VGND sky130_ef_sc_hd__decap_12
X_2972_ _2922_/A _2922_/B _2922_/C _2947_/A _2915_/A VGND VGND VPWR VPWR _2973_/B
+ sky130_fd_sc_hd__o311a_1
X_4711_ _4712_/CLK _4711_/D fanout172/X VGND VGND VPWR VPWR _4711_/Q sky130_fd_sc_hd__dfrtp_1
X_4642_ _4676_/CLK _4642_/D fanout134/X VGND VGND VPWR VPWR _4642_/Q sky130_fd_sc_hd__dfrtp_1
XTAP_TAPCELL_ROW_32_579 VGND VPWR sky130_fd_sc_hd__tapvpwrvgnd_1
XTAP_TAPCELL_ROW_60_888 VGND VPWR sky130_fd_sc_hd__tapvpwrvgnd_1
X_4573_ _4752_/CLK _4573_/D fanout133/X VGND VGND VPWR VPWR _4573_/Q sky130_fd_sc_hd__dfrtp_1
X_3524_ _3575_/A _3575_/B VGND VGND VPWR VPWR _3534_/A sky130_fd_sc_hd__xor2_2
XFILLER_89_529 VPWR VGND VPWR VGND sky130_ef_sc_hd__decap_12
X_3455_ _3436_/A _3436_/B _3433_/Y VGND VGND VPWR VPWR _3461_/A sky130_fd_sc_hd__a21bo_1
XFILLER_103_317 VPWR VGND VPWR VGND sky130_ef_sc_hd__decap_12
X_2406_ hold208/X _2407_/A2 _2407_/B1 _4507_/Q VGND VGND VPWR VPWR _2406_/X sky130_fd_sc_hd__a22o_1
X_3386_ _3384_/Y _3385_/X _3382_/A _3470_/B2 VGND VGND VPWR VPWR _4527_/D sky130_fd_sc_hd__a2bb2o_1
XFILLER_97_573 VPWR VGND VPWR VGND sky130_ef_sc_hd__decap_12
X_2337_ _2356_/A hold1/X VGND VGND VPWR VPWR _4365_/D sky130_fd_sc_hd__and2_1
X_2268_ _4712_/Q _2521_/A _2206_/Y _4466_/Q VGND VGND VPWR VPWR _2269_/C sky130_fd_sc_hd__a22o_1
XFILLER_72_429 VPWR VGND VPWR VGND sky130_ef_sc_hd__decap_12
XFILLER_72_407 VPWR VGND VPWR VGND sky130_ef_sc_hd__decap_12
XTAP_TAPCELL_ROW_68_977 VGND VPWR sky130_fd_sc_hd__tapvpwrvgnd_1
X_4007_ hold161/X _4735_/Q _4007_/S VGND VGND VPWR VPWR _4564_/D sky130_fd_sc_hd__mux2_1
XFILLER_37_150 VGND VGND VPWR VPWR sky130_fd_sc_hd__fill_1
X_2199_ _4715_/Q VGND VGND VPWR VPWR _2199_/Y sky130_fd_sc_hd__inv_2
XFILLER_80_462 VPWR VGND VPWR VGND sky130_ef_sc_hd__decap_12
XFILLER_71_39 VPWR VGND VPWR VGND sky130_ef_sc_hd__decap_12
XFILLER_52_197 VPWR VGND VPWR VGND sky130_ef_sc_hd__decap_12
XFILLER_21_573 VGND VGND VPWR VPWR sky130_fd_sc_hd__decap_4
XFILLER_107_601 VPWR VGND VPWR VGND sky130_ef_sc_hd__decap_12
XFILLER_106_133 VGND VGND VPWR VPWR sky130_fd_sc_hd__decap_6
XTAP_TAPCELL_ROW_91_1228 VGND VPWR sky130_fd_sc_hd__tapvpwrvgnd_1
XFILLER_20_65 VPWR VGND VPWR VGND sky130_ef_sc_hd__decap_12
XFILLER_106_177 VPWR VGND VPWR VGND sky130_ef_sc_hd__decap_12
XFILLER_0_444 VGND VGND VPWR VPWR sky130_fd_sc_hd__decap_4
Xhold41 hold41/A VGND VGND VPWR VPWR hold41/X sky130_fd_sc_hd__dlygate4sd3_1
Xhold30 hold30/A VGND VGND VPWR VPWR hold30/X sky130_fd_sc_hd__dlygate4sd3_1
Xhold74 hold74/A VGND VGND VPWR VPWR hold74/X sky130_fd_sc_hd__dlygate4sd3_1
Xhold63 hold63/A VGND VGND VPWR VPWR hold63/X sky130_fd_sc_hd__dlygate4sd3_1
Xhold52 hold52/A VGND VGND VPWR VPWR hold52/X sky130_fd_sc_hd__dlygate4sd3_1
Xhold85 hold85/A VGND VGND VPWR VPWR hold85/X sky130_fd_sc_hd__dlygate4sd3_1
XTAP_TAPCELL_ROW_3_260 VGND VPWR sky130_fd_sc_hd__tapvpwrvgnd_1
Xhold96 hold96/A VGND VGND VPWR VPWR hold96/X sky130_fd_sc_hd__dlygate4sd3_1
XFILLER_45_51 VGND VGND VPWR VPWR sky130_fd_sc_hd__decap_4
XFILLER_31_337 VGND VGND VPWR VPWR sky130_fd_sc_hd__fill_1
XTAP_TAPCELL_ROW_100_1335 VGND VPWR sky130_fd_sc_hd__tapvpwrvgnd_1
XFILLER_12_584 VGND VGND VPWR VPWR sky130_fd_sc_hd__decap_4
XFILLER_8_555 VGND VGND VPWR VPWR sky130_fd_sc_hd__decap_4
XFILLER_8_533 VGND VGND VPWR VPWR sky130_fd_sc_hd__decap_6
X_3240_ _3240_/A _3240_/B VGND VGND VPWR VPWR _3242_/B sky130_fd_sc_hd__xnor2_1
XFILLER_3_293 VPWR VGND VPWR VGND sky130_ef_sc_hd__decap_12
XFILLER_100_309 VPWR VGND VPWR VGND sky130_ef_sc_hd__decap_12
XFILLER_79_573 VPWR VGND VPWR VGND sky130_ef_sc_hd__decap_12
X_3171_ _3171_/A _3171_/B VGND VGND VPWR VPWR _3967_/A sky130_fd_sc_hd__xnor2_2
XFILLER_13_3 VPWR VGND VPWR VGND sky130_ef_sc_hd__decap_12
XFILLER_94_587 VGND VGND VPWR VPWR sky130_fd_sc_hd__fill_1
XFILLER_54_418 VGND VGND VPWR VPWR sky130_fd_sc_hd__fill_2
XFILLER_81_237 VGND VGND VPWR VPWR sky130_fd_sc_hd__fill_2
XTAP_TAPCELL_ROW_65_947 VGND VPWR sky130_fd_sc_hd__tapvpwrvgnd_1
XTAP_TAPCELL_ROW_37_638 VGND VPWR sky130_fd_sc_hd__tapvpwrvgnd_1
XFILLER_62_473 VGND VGND VPWR VPWR sky130_fd_sc_hd__decap_3
XFILLER_22_337 VGND VGND VPWR VPWR sky130_fd_sc_hd__decap_8
X_2955_ _2933_/A _2933_/B _2928_/A VGND VGND VPWR VPWR _2956_/B sky130_fd_sc_hd__a21oi_2
X_2886_ _2884_/Y _2886_/B VGND VGND VPWR VPWR _2892_/B sky130_fd_sc_hd__nand2b_1
X_4625_ _4740_/CLK _4625_/D fanout122/X VGND VGND VPWR VPWR hold88/A sky130_fd_sc_hd__dfrtp_1
X_4556_ _4752_/CLK _4556_/D fanout133/X VGND VGND VPWR VPWR _4556_/Q sky130_fd_sc_hd__dfrtp_2
X_3507_ _3526_/B _3507_/B VGND VGND VPWR VPWR _3508_/B sky130_fd_sc_hd__xnor2_1
XFILLER_89_337 VGND VGND VPWR VPWR sky130_fd_sc_hd__fill_2
XTAP_TAPCELL_ROW_77_1083 VGND VPWR sky130_fd_sc_hd__tapvpwrvgnd_1
X_4487_ _4727_/CLK _4487_/D fanout150/X VGND VGND VPWR VPWR _4487_/Q sky130_fd_sc_hd__dfrtp_1
XFILLER_103_125 VPWR VGND VPWR VGND sky130_ef_sc_hd__decap_12
X_3438_ _3438_/A _3648_/A VGND VGND VPWR VPWR _3440_/B sky130_fd_sc_hd__xnor2_1
XFILLER_103_169 VPWR VGND VPWR VGND sky130_ef_sc_hd__decap_12
X_3369_ _3369_/A _3369_/B VGND VGND VPWR VPWR _3370_/B sky130_fd_sc_hd__or2_1
XTAP_TAPCELL_ROW_0_230 VGND VPWR sky130_fd_sc_hd__tapvpwrvgnd_1
XFILLER_26_610 VGND VGND VPWR VPWR sky130_fd_sc_hd__fill_1
XFILLER_38_470 VGND VGND VPWR VPWR sky130_fd_sc_hd__decap_6
XFILLER_82_27 VGND VGND VPWR VPWR sky130_fd_sc_hd__fill_1
XFILLER_25_164 VGND VGND VPWR VPWR sky130_fd_sc_hd__decap_4
XFILLER_25_175 VGND VGND VPWR VPWR sky130_fd_sc_hd__decap_6
XFILLER_41_602 VGND VGND VPWR VPWR sky130_fd_sc_hd__fill_1
XFILLER_13_337 VGND VGND VPWR VPWR sky130_fd_sc_hd__fill_1
XFILLER_40_123 VGND VGND VPWR VPWR sky130_fd_sc_hd__fill_1
XFILLER_40_189 VGND VGND VPWR VPWR sky130_fd_sc_hd__decap_6
XFILLER_5_525 VGND VGND VPWR VPWR sky130_fd_sc_hd__fill_2
XFILLER_76_587 VGND VGND VPWR VPWR sky130_fd_sc_hd__fill_1
XFILLER_48_278 VGND VGND VPWR VPWR sky130_fd_sc_hd__decap_8
XFILLER_56_83 VGND VGND VPWR VPWR sky130_fd_sc_hd__fill_1
XFILLER_29_492 VGND VGND VPWR VPWR sky130_fd_sc_hd__decap_3
XTAP_TAPCELL_ROW_62_917 VGND VPWR sky130_fd_sc_hd__tapvpwrvgnd_1
XFILLER_16_153 VGND VGND VPWR VPWR sky130_fd_sc_hd__decap_8
XTAP_TAPCELL_ROW_34_608 VGND VPWR sky130_fd_sc_hd__tapvpwrvgnd_1
XFILLER_71_281 VGND VGND VPWR VPWR sky130_fd_sc_hd__decap_6
XFILLER_31_167 VGND VGND VPWR VPWR sky130_fd_sc_hd__fill_1
XTAP_TAPCELL_ROW_14_387 VGND VPWR sky130_fd_sc_hd__tapvpwrvgnd_1
XFILLER_12_381 VGND VGND VPWR VPWR sky130_fd_sc_hd__decap_8
X_2740_ _3382_/A _4536_/Q VGND VGND VPWR VPWR _2741_/C sky130_fd_sc_hd__nand2_1
XTAP_TAPCELL_ROW_42_696 VGND VPWR sky130_fd_sc_hd__tapvpwrvgnd_1
X_2671_ _4742_/Q _2672_/B VGND VGND VPWR VPWR _2671_/X sky130_fd_sc_hd__or2_1
X_4410_ _4495_/CLK _4410_/D fanout129/X VGND VGND VPWR VPWR _4410_/Q sky130_fd_sc_hd__dfrtp_1
X_4341_ _4753_/Q _4345_/A2 _3657_/A _4345_/B2 VGND VGND VPWR VPWR _4753_/D sky130_fd_sc_hd__a22o_1
X_4272_ _4283_/A _4271_/Y _4269_/Y _2250_/A VGND VGND VPWR VPWR _4273_/B sky130_fd_sc_hd__a211o_1
XFILLER_101_629 VGND VGND VPWR VPWR sky130_fd_sc_hd__decap_8
XFILLER_98_189 VGND VGND VPWR VPWR sky130_fd_sc_hd__decap_6
XFILLER_86_307 VGND VGND VPWR VPWR sky130_fd_sc_hd__fill_1
X_3223_ _3224_/B _4519_/Q VGND VGND VPWR VPWR _3223_/X sky130_fd_sc_hd__and2b_1
XFILLER_100_139 VGND VGND VPWR VPWR sky130_fd_sc_hd__fill_1
X_3154_ _4583_/Q hold38/A _4647_/Q hold70/A _4324_/S _3174_/S1 VGND VGND VPWR VPWR
+ _3156_/B sky130_fd_sc_hd__mux4_1
XFILLER_82_513 VPWR VGND VPWR VGND sky130_ef_sc_hd__decap_12
X_3085_ _3083_/X _3085_/B VGND VGND VPWR VPWR _3087_/A sky130_fd_sc_hd__nand2b_1
XPHY_EDGE_ROW_6_Left_114 VGND VGND VPWR VPWR sky130_fd_sc_hd__decap_3
XFILLER_82_557 VPWR VGND VPWR VGND sky130_ef_sc_hd__decap_12
XFILLER_50_421 VGND VGND VPWR VPWR sky130_fd_sc_hd__fill_2
X_3987_ _3987_/A _3987_/B VGND VGND VPWR VPWR _3988_/B sky130_fd_sc_hd__xnor2_1
XFILLER_10_307 VGND VGND VPWR VPWR sky130_fd_sc_hd__fill_1
XFILLER_10_329 VGND VGND VPWR VPWR sky130_fd_sc_hd__fill_1
X_2938_ _4753_/Q _2938_/B VGND VGND VPWR VPWR _2939_/B sky130_fd_sc_hd__nand2_1
XTAP_TAPCELL_ROW_79_1101 VGND VPWR sky130_fd_sc_hd__tapvpwrvgnd_1
X_2869_ _2869_/A _2869_/B VGND VGND VPWR VPWR _2916_/A sky130_fd_sc_hd__nand2_1
X_4608_ _4676_/CLK _4608_/D fanout134/X VGND VGND VPWR VPWR _4608_/Q sky130_fd_sc_hd__dfrtp_1
XFILLER_104_401 VPWR VGND VPWR VGND sky130_ef_sc_hd__decap_12
X_4539_ _4539_/CLK _4539_/D fanout169/X VGND VGND VPWR VPWR _4539_/Q sky130_fd_sc_hd__dfrtp_4
XFILLER_104_445 VPWR VGND VPWR VGND sky130_ef_sc_hd__decap_12
XFILLER_89_145 VGND VGND VPWR VPWR sky130_fd_sc_hd__fill_1
XFILLER_77_27 VPWR VGND VPWR VGND sky130_ef_sc_hd__decap_12
XFILLER_104_489 VPWR VGND VPWR VGND sky130_ef_sc_hd__decap_12
XFILLER_89_167 VGND VGND VPWR VPWR sky130_fd_sc_hd__fill_1
XFILLER_93_15 VPWR VGND VPWR VGND sky130_ef_sc_hd__decap_12
XFILLER_85_384 VGND VGND VPWR VPWR sky130_fd_sc_hd__fill_2
XFILLER_18_418 VGND VGND VPWR VPWR sky130_fd_sc_hd__fill_2
XFILLER_45_204 VGND VGND VPWR VPWR sky130_fd_sc_hd__decap_8
XFILLER_58_587 VGND VGND VPWR VPWR sky130_fd_sc_hd__fill_1
Xclkbuf_3_6__f_clk clkbuf_0_clk/X VGND VGND VPWR VPWR clkload5/A sky130_fd_sc_hd__clkbuf_16
XFILLER_26_53 VPWR VGND VPWR VGND sky130_ef_sc_hd__decap_12
XFILLER_41_432 VGND VGND VPWR VPWR sky130_fd_sc_hd__fill_1
XFILLER_53_281 VGND VGND VPWR VPWR sky130_fd_sc_hd__decap_6
XFILLER_42_41 VPWR VGND VPWR VGND sky130_ef_sc_hd__decap_12
XTAP_TAPCELL_ROW_11_357 VGND VPWR sky130_fd_sc_hd__tapvpwrvgnd_1
XFILLER_5_388 VGND VGND VPWR VPWR sky130_fd_sc_hd__decap_4
XFILLER_68_307 VGND VGND VPWR VPWR sky130_fd_sc_hd__fill_1
XFILLER_1_550 VGND VGND VPWR VPWR sky130_fd_sc_hd__decap_8
XFILLER_1_561 VPWR VGND VPWR VGND sky130_ef_sc_hd__decap_12
XFILLER_95_137 VPWR VGND VPWR VGND sky130_ef_sc_hd__decap_12
XPHY_EDGE_ROW_79_Left_187 VGND VGND VPWR VPWR sky130_fd_sc_hd__decap_3
XFILLER_3_57 VPWR VGND VPWR VGND sky130_ef_sc_hd__decap_12
XFILLER_91_321 VGND VGND VPWR VPWR sky130_fd_sc_hd__fill_1
XFILLER_64_513 VPWR VGND VPWR VGND sky130_ef_sc_hd__decap_12
XFILLER_36_226 VGND VGND VPWR VPWR sky130_fd_sc_hd__fill_2
XFILLER_91_354 VGND VGND VPWR VPWR sky130_fd_sc_hd__decap_3
XFILLER_64_557 VPWR VGND VPWR VGND sky130_ef_sc_hd__decap_12
XTAP_TAPCELL_ROW_19_446 VGND VPWR sky130_fd_sc_hd__tapvpwrvgnd_1
XTAP_TAPCELL_ROW_47_744 VGND VPWR sky130_fd_sc_hd__tapvpwrvgnd_1
XFILLER_91_387 VGND VGND VPWR VPWR sky130_fd_sc_hd__decap_4
XTAP_TAPCELL_ROW_106_1396 VGND VPWR sky130_fd_sc_hd__tapvpwrvgnd_1
X_3910_ _3886_/Y _3890_/Y _3931_/B _3845_/A VGND VGND VPWR VPWR _3910_/X sky130_fd_sc_hd__a31o_1
XFILLER_83_81 VGND VGND VPWR VPWR sky130_fd_sc_hd__decap_3
XFILLER_32_421 VPWR VGND VPWR VGND sky130_ef_sc_hd__decap_12
XPHY_EDGE_ROW_88_Left_196 VGND VGND VPWR VPWR sky130_fd_sc_hd__decap_3
X_3841_ _4545_/Q _3810_/B _3791_/B _4544_/Q VGND VGND VPWR VPWR _3841_/X sky130_fd_sc_hd__o211a_1
XFILLER_80_3 VPWR VGND VPWR VGND sky130_ef_sc_hd__decap_12
X_3772_ _4643_/Q _4579_/Q _4675_/Q _4611_/Q _3983_/S0 _3983_/S1 VGND VGND VPWR VPWR
+ _3774_/B sky130_fd_sc_hd__mux4_1
X_2723_ _4530_/Q _2723_/B VGND VGND VPWR VPWR _2820_/A sky130_fd_sc_hd__xnor2_1
X_2654_ _4532_/Q _4523_/Q VGND VGND VPWR VPWR _2658_/B sky130_fd_sc_hd__or2_1
X_2585_ _2585_/A _2585_/B VGND VGND VPWR VPWR _2587_/B sky130_fd_sc_hd__xnor2_1
XTAP_TAPCELL_ROW_74_1042 VGND VPWR sky130_fd_sc_hd__tapvpwrvgnd_1
X_4324_ _4345_/B2 _4345_/A2 _4324_/S VGND VGND VPWR VPWR _4736_/D sky130_fd_sc_hd__mux2_1
Xfanout106 _4544_/Q VGND VGND VPWR VPWR _3791_/A sky130_fd_sc_hd__clkbuf_4
Xfanout128 fanout173/X VGND VGND VPWR VPWR fanout128/X sky130_fd_sc_hd__buf_2
Xfanout117 _4361_/Q VGND VGND VPWR VPWR _4140_/B sky130_fd_sc_hd__clkbuf_2
Xfanout139 fanout142/X VGND VGND VPWR VPWR fanout139/X sky130_fd_sc_hd__clkbuf_4
X_4255_ _4259_/B VGND VGND VPWR VPWR _4255_/Y sky130_fd_sc_hd__inv_2
X_3206_ _4518_/Q _3207_/B VGND VGND VPWR VPWR _3206_/X sky130_fd_sc_hd__or2_1
X_4186_ _4213_/A1 _4184_/Y _4185_/X _4217_/B1 _4693_/Q VGND VGND VPWR VPWR _4693_/D
+ sky130_fd_sc_hd__a32o_1
X_3137_ _3137_/A _3137_/B VGND VGND VPWR VPWR _3146_/A sky130_fd_sc_hd__xor2_1
XFILLER_27_204 VGND VGND VPWR VPWR sky130_fd_sc_hd__decap_3
XFILLER_55_502 VGND VGND VPWR VPWR sky130_fd_sc_hd__fill_2
XFILLER_55_513 VGND VGND VPWR VPWR sky130_fd_sc_hd__fill_1
XFILLER_55_535 VPWR VGND VPWR VGND sky130_ef_sc_hd__decap_12
XFILLER_82_332 VGND VGND VPWR VPWR sky130_fd_sc_hd__decap_6
XFILLER_82_321 VGND VGND VPWR VPWR sky130_fd_sc_hd__decap_4
XFILLER_103_69 VPWR VGND VPWR VGND sky130_ef_sc_hd__decap_12
XFILLER_82_365 VPWR VGND VPWR VGND sky130_ef_sc_hd__decap_12
X_3068_ _3066_/X _3068_/B VGND VGND VPWR VPWR _3071_/A sky130_fd_sc_hd__nand2b_1
XTAP_TAPCELL_ROW_85_1171 VGND VPWR sky130_fd_sc_hd__tapvpwrvgnd_1
XFILLER_23_410 VGND VGND VPWR VPWR sky130_fd_sc_hd__decap_8
XFILLER_35_281 VGND VGND VPWR VPWR sky130_fd_sc_hd__decap_8
XFILLER_50_251 VGND VGND VPWR VPWR sky130_fd_sc_hd__fill_1
XFILLER_12_77 VGND VGND VPWR VPWR sky130_fd_sc_hd__decap_6
XFILLER_88_15 VPWR VGND VPWR VGND sky130_ef_sc_hd__decap_12
Xhold160 _4583_/Q VGND VGND VPWR VPWR hold160/X sky130_fd_sc_hd__dlygate4sd3_1
Xhold171 _4592_/Q VGND VGND VPWR VPWR hold171/X sky130_fd_sc_hd__dlygate4sd3_1
XFILLER_2_325 VGND VGND VPWR VPWR sky130_fd_sc_hd__fill_1
XFILLER_104_253 VPWR VGND VPWR VGND sky130_ef_sc_hd__decap_12
Xhold182 _4609_/Q VGND VGND VPWR VPWR hold182/X sky130_fd_sc_hd__dlygate4sd3_1
Xhold193 _4591_/Q VGND VGND VPWR VPWR hold193/X sky130_fd_sc_hd__dlygate4sd3_1
XFILLER_58_373 VGND VGND VPWR VPWR sky130_fd_sc_hd__fill_2
XFILLER_73_387 VGND VGND VPWR VPWR sky130_fd_sc_hd__decap_4
XFILLER_61_505 VPWR VGND VPWR VGND sky130_ef_sc_hd__decap_12
XTAP_TAPCELL_ROW_16_405 VGND VPWR sky130_fd_sc_hd__tapvpwrvgnd_1
XTAP_TAPCELL_ROW_44_714 VGND VPWR sky130_fd_sc_hd__tapvpwrvgnd_1
XFILLER_53_51 VGND VGND VPWR VPWR sky130_fd_sc_hd__decap_4
XTAP_TAPCELL_ROW_99_1318 VGND VPWR sky130_fd_sc_hd__tapvpwrvgnd_1
XTAP_TAPCELL_ROW_24_493 VGND VPWR sky130_fd_sc_hd__tapvpwrvgnd_1
XFILLER_96_413 VGND VGND VPWR VPWR sky130_fd_sc_hd__decap_6
XFILLER_68_104 VGND VGND VPWR VPWR sky130_fd_sc_hd__decap_4
X_2370_ hold26/X _2379_/A2 _2379_/B1 _4535_/Q VGND VGND VPWR VPWR _4385_/D sky130_fd_sc_hd__a22o_1
XFILLER_96_457 VPWR VGND VPWR VGND sky130_ef_sc_hd__decap_12
X_4040_ _4139_/A1 hold142/X _4040_/S VGND VGND VPWR VPWR _4580_/D sky130_fd_sc_hd__mux2_1
XFILLER_49_351 VGND VGND VPWR VPWR sky130_fd_sc_hd__decap_4
XFILLER_49_384 VGND VGND VPWR VPWR sky130_fd_sc_hd__decap_8
XFILLER_91_162 VGND VGND VPWR VPWR sky130_fd_sc_hd__decap_6
XFILLER_64_365 VGND VGND VPWR VPWR sky130_fd_sc_hd__decap_8
XFILLER_24_218 VPWR VGND VPWR VGND sky130_ef_sc_hd__decap_12
XPHY_EDGE_ROW_96_Left_204 VGND VGND VPWR VPWR sky130_fd_sc_hd__decap_3
XFILLER_20_413 VGND VGND VPWR VPWR sky130_fd_sc_hd__fill_2
X_3824_ _3824_/A _3947_/B VGND VGND VPWR VPWR _3826_/B sky130_fd_sc_hd__xnor2_1
X_3755_ _4756_/Q _4757_/Q _3755_/C VGND VGND VPWR VPWR _3800_/C sky130_fd_sc_hd__or3_1
XFILLER_20_468 VGND VGND VPWR VPWR sky130_fd_sc_hd__decap_8
X_3686_ _4540_/Q _3718_/B VGND VGND VPWR VPWR _3687_/B sky130_fd_sc_hd__nor2_1
X_2706_ _2704_/X _2706_/B VGND VGND VPWR VPWR _2707_/B sky130_fd_sc_hd__nand2b_2
XPHY_EDGE_ROW_12_Right_12 VGND VGND VPWR VPWR sky130_fd_sc_hd__decap_3
X_2637_ _2637_/A _2637_/B VGND VGND VPWR VPWR _2639_/A sky130_fd_sc_hd__nand2_1
X_2568_ _3278_/A _2569_/B VGND VGND VPWR VPWR _2581_/A sky130_fd_sc_hd__nand2_1
XFILLER_58_29 VPWR VGND VPWR VGND sky130_ef_sc_hd__decap_12
XFILLER_101_223 VGND VGND VPWR VPWR sky130_fd_sc_hd__fill_1
XFILLER_99_273 VGND VGND VPWR VPWR sky130_fd_sc_hd__decap_6
XFILLER_87_446 VGND VGND VPWR VPWR sky130_fd_sc_hd__fill_2
X_2499_ _4461_/Q _2501_/C _2526_/A1 VGND VGND VPWR VPWR _2499_/Y sky130_fd_sc_hd__o21ai_1
X_4307_ _4318_/A _4306_/Y _4304_/Y _2250_/A VGND VGND VPWR VPWR _4308_/B sky130_fd_sc_hd__a211o_1
X_4238_ _4238_/A1 _4240_/B _4237_/X _4238_/B1 hold282/X VGND VGND VPWR VPWR _4708_/D
+ sky130_fd_sc_hd__a32o_1
X_4169_ _4688_/Q _4689_/Q _4169_/C VGND VGND VPWR VPWR _4176_/C sky130_fd_sc_hd__and3_1
XFILLER_82_162 VGND VGND VPWR VPWR sky130_fd_sc_hd__decap_4
XFILLER_15_207 VPWR VGND VPWR VGND sky130_ef_sc_hd__decap_12
XPHY_EDGE_ROW_21_Right_21 VGND VGND VPWR VPWR sky130_fd_sc_hd__decap_3
XFILLER_90_27 VGND VGND VPWR VPWR sky130_fd_sc_hd__fill_1
XFILLER_7_428 VGND VGND VPWR VPWR sky130_fd_sc_hd__decap_4
XTAP_TAPCELL_ROW_21_463 VGND VPWR sky130_fd_sc_hd__tapvpwrvgnd_1
XPHY_EDGE_ROW_30_Right_30 VGND VGND VPWR VPWR sky130_fd_sc_hd__decap_3
XFILLER_99_69 VPWR VGND VPWR VGND sky130_ef_sc_hd__decap_12
XFILLER_78_402 VGND VGND VPWR VPWR sky130_fd_sc_hd__decap_6
XFILLER_2_133 VGND VGND VPWR VPWR sky130_fd_sc_hd__decap_6
XFILLER_105_573 VPWR VGND VPWR VGND sky130_ef_sc_hd__decap_12
XFILLER_93_405 VPWR VGND VPWR VGND sky130_ef_sc_hd__decap_12
XFILLER_19_502 VGND VGND VPWR VPWR sky130_fd_sc_hd__fill_2
XFILLER_48_73 VGND VGND VPWR VPWR sky130_fd_sc_hd__fill_1
XFILLER_93_449 VPWR VGND VPWR VGND sky130_ef_sc_hd__decap_12
XFILLER_0_69 VPWR VGND VPWR VGND sky130_ef_sc_hd__decap_12
XTAP_TAPCELL_ROW_29_552 VGND VPWR sky130_fd_sc_hd__tapvpwrvgnd_1
XFILLER_34_505 VGND VGND VPWR VPWR sky130_fd_sc_hd__decap_6
XTAP_TAPCELL_ROW_57_861 VGND VPWR sky130_fd_sc_hd__tapvpwrvgnd_1
XFILLER_64_94 VGND VGND VPWR VPWR sky130_fd_sc_hd__decap_3
XFILLER_64_83 VGND VGND VPWR VPWR sky130_fd_sc_hd__fill_1
XTAP_TAPCELL_ROW_103_1366 VGND VPWR sky130_fd_sc_hd__tapvpwrvgnd_1
XFILLER_14_284 VPWR VGND VPWR VGND sky130_ef_sc_hd__decap_12
XFILLER_9_89 VGND VGND VPWR VPWR sky130_fd_sc_hd__fill_1
X_3540_ _3633_/A _3530_/B _3533_/A VGND VGND VPWR VPWR _3550_/A sky130_fd_sc_hd__a21o_1
XFILLER_10_490 VGND VGND VPWR VPWR sky130_fd_sc_hd__decap_6
X_3471_ _4745_/Q _3456_/B _4746_/Q VGND VGND VPWR VPWR _3472_/B sky130_fd_sc_hd__a21oi_1
X_2422_ _2422_/A _2422_/B VGND VGND VPWR VPWR _2422_/Y sky130_fd_sc_hd__nor2_1
XFILLER_43_3 VPWR VGND VPWR VGND sky130_ef_sc_hd__decap_12
XFILLER_96_221 VPWR VGND VPWR VGND sky130_ef_sc_hd__decap_12
XTAP_TAPCELL_ROW_71_1012 VGND VPWR sky130_fd_sc_hd__tapvpwrvgnd_1
X_2353_ _4717_/Q _4368_/Q VGND VGND VPWR VPWR _2423_/B sky130_fd_sc_hd__nor2_1
XFILLER_96_265 VPWR VGND VPWR VGND sky130_ef_sc_hd__decap_12
X_2284_ _4703_/Q _2214_/Y _2282_/X _2283_/Y VGND VGND VPWR VPWR _2316_/B sky130_fd_sc_hd__o211a_1
X_4023_ _4095_/B _4016_/B _4135_/A1 _4016_/Y hold69/X VGND VGND VPWR VPWR _4568_/D
+ sky130_fd_sc_hd__a32o_1
XFILLER_49_181 VGND VGND VPWR VPWR sky130_fd_sc_hd__fill_2
XFILLER_25_505 VPWR VGND VPWR VGND sky130_ef_sc_hd__decap_12
XFILLER_64_195 VGND VGND VPWR VPWR sky130_fd_sc_hd__fill_1
XFILLER_37_387 VGND VGND VPWR VPWR sky130_fd_sc_hd__decap_4
XFILLER_52_302 VGND VGND VPWR VPWR sky130_fd_sc_hd__fill_1
XTAP_TAPCELL_ROW_82_1130 VGND VPWR sky130_fd_sc_hd__tapvpwrvgnd_1
XFILLER_100_15 VPWR VGND VPWR VGND sky130_ef_sc_hd__decap_12
X_3807_ _3807_/A _3820_/B VGND VGND VPWR VPWR _3808_/B sky130_fd_sc_hd__xor2_1
X_3738_ _3824_/A _3738_/B VGND VGND VPWR VPWR _3740_/C sky130_fd_sc_hd__xnor2_1
XFILLER_69_39 VPWR VGND VPWR VGND sky130_ef_sc_hd__decap_12
X_3669_ hold96/A _4575_/Q _4671_/Q _4607_/Q _3915_/S0 _3915_/S1 VGND VGND VPWR VPWR
+ _3670_/A sky130_fd_sc_hd__mux4_1
XFILLER_87_221 VGND VGND VPWR VPWR sky130_fd_sc_hd__decap_3
XFILLER_102_587 VGND VGND VPWR VPWR sky130_fd_sc_hd__fill_1
XFILLER_87_287 VGND VGND VPWR VPWR sky130_fd_sc_hd__fill_1
XFILLER_87_265 VPWR VGND VPWR VGND sky130_ef_sc_hd__decap_12
XFILLER_85_27 VPWR VGND VPWR VGND sky130_ef_sc_hd__decap_12
XFILLER_75_405 VGND VGND VPWR VPWR sky130_fd_sc_hd__fill_2
XFILLER_18_65 VPWR VGND VPWR VGND sky130_ef_sc_hd__decap_12
XFILLER_28_365 VGND VGND VPWR VPWR sky130_fd_sc_hd__decap_4
XTAP_TAPCELL_ROW_26_522 VGND VPWR sky130_fd_sc_hd__tapvpwrvgnd_1
XTAP_TAPCELL_ROW_54_831 VGND VPWR sky130_fd_sc_hd__tapvpwrvgnd_1
XFILLER_34_53 VGND VGND VPWR VPWR sky130_fd_sc_hd__decap_8
XFILLER_11_254 VPWR VGND VPWR VGND sky130_ef_sc_hd__decap_12
XFILLER_11_298 VPWR VGND VPWR VGND sky130_ef_sc_hd__decap_12
XFILLER_50_41 VPWR VGND VPWR VGND sky130_ef_sc_hd__decap_12
XFILLER_50_85 VGND VGND VPWR VPWR sky130_fd_sc_hd__decap_8
XFILLER_78_287 VPWR VGND VPWR VGND sky130_ef_sc_hd__decap_12
XFILLER_66_427 VGND VGND VPWR VPWR sky130_fd_sc_hd__fill_1
XFILLER_66_416 VGND VGND VPWR VPWR sky130_fd_sc_hd__decap_4
XFILLER_74_471 VGND VGND VPWR VPWR sky130_fd_sc_hd__decap_4
X_2971_ _2971_/A _2971_/B VGND VGND VPWR VPWR _3013_/A sky130_fd_sc_hd__nand2_1
XFILLER_91_81 VGND VGND VPWR VPWR sky130_fd_sc_hd__fill_1
XFILLER_61_198 VGND VGND VPWR VPWR sky130_fd_sc_hd__fill_1
X_4710_ _4712_/CLK _4710_/D fanout172/X VGND VGND VPWR VPWR _4710_/Q sky130_fd_sc_hd__dfrtp_2
X_4641_ _4756_/CLK _4641_/D fanout134/X VGND VGND VPWR VPWR _4641_/Q sky130_fd_sc_hd__dfrtp_1
XTAP_TAPCELL_ROW_60_889 VGND VPWR sky130_fd_sc_hd__tapvpwrvgnd_1
X_4572_ clkload8/A _4572_/D fanout127/X VGND VGND VPWR VPWR hold47/A sky130_fd_sc_hd__dfrtp_1
X_3523_ _3599_/S0 _3521_/X _3522_/Y _3520_/X VGND VGND VPWR VPWR _3575_/B sky130_fd_sc_hd__a31o_1
X_3454_ _3525_/B _3525_/C VGND VGND VPWR VPWR _3462_/A sky130_fd_sc_hd__nand2_1
XFILLER_103_329 VGND VGND VPWR VPWR sky130_fd_sc_hd__decap_6
XFILLER_69_210 VGND VGND VPWR VPWR sky130_fd_sc_hd__fill_1
X_2405_ hold103/X _2407_/A2 _2407_/B1 _4506_/Q VGND VGND VPWR VPWR _4420_/D sky130_fd_sc_hd__a22o_1
XFILLER_97_541 VPWR VGND VPWR VGND sky130_ef_sc_hd__decap_12
XFILLER_69_232 VPWR VGND VPWR VGND sky130_ef_sc_hd__decap_12
X_3385_ _3363_/X _3382_/X _3383_/Y _2325_/C VGND VGND VPWR VPWR _3385_/X sky130_fd_sc_hd__a31o_1
XFILLER_97_585 VPWR VGND VPWR VGND sky130_ef_sc_hd__decap_12
X_2336_ input9/X _4718_/D VGND VGND VPWR VPWR _4735_/D sky130_fd_sc_hd__and2_1
XFILLER_84_213 VPWR VGND VPWR VGND sky130_ef_sc_hd__decap_12
Xclkbuf_leaf_49_clk clkload4/A VGND VGND VPWR VPWR _4501_/CLK sky130_fd_sc_hd__clkbuf_8
X_2267_ _4711_/Q _4467_/Q VGND VGND VPWR VPWR _2269_/B sky130_fd_sc_hd__xor2_1
XFILLER_57_438 VGND VGND VPWR VPWR sky130_fd_sc_hd__decap_8
XFILLER_57_449 VGND VGND VPWR VPWR sky130_fd_sc_hd__fill_1
XFILLER_84_279 VGND VGND VPWR VPWR sky130_fd_sc_hd__decap_8
XFILLER_72_419 VGND VGND VPWR VPWR sky130_fd_sc_hd__fill_1
XTAP_TAPCELL_ROW_68_978 VGND VPWR sky130_fd_sc_hd__tapvpwrvgnd_1
X_4006_ hold141/X _4734_/Q _4007_/S VGND VGND VPWR VPWR _4563_/D sky130_fd_sc_hd__mux2_1
X_2198_ _4472_/Q VGND VGND VPWR VPWR _2198_/Y sky130_fd_sc_hd__inv_2
XFILLER_80_474 VGND VGND VPWR VPWR sky130_fd_sc_hd__fill_2
XFILLER_107_613 VGND VGND VPWR VPWR sky130_fd_sc_hd__decap_3
XTAP_TAPCELL_ROW_91_1229 VGND VPWR sky130_fd_sc_hd__tapvpwrvgnd_1
XFILLER_20_77 VGND VGND VPWR VPWR sky130_fd_sc_hd__decap_6
XFILLER_106_189 VGND VGND VPWR VPWR sky130_fd_sc_hd__decap_6
XFILLER_96_15 VPWR VGND VPWR VGND sky130_ef_sc_hd__decap_12
Xhold20 hold20/A VGND VGND VPWR VPWR hold20/X sky130_fd_sc_hd__dlygate4sd3_1
Xhold31 hold31/A VGND VGND VPWR VPWR hold31/X sky130_fd_sc_hd__dlygate4sd3_1
Xhold64 hold64/A VGND VGND VPWR VPWR hold64/X sky130_fd_sc_hd__dlygate4sd3_1
Xhold53 hold53/A VGND VGND VPWR VPWR hold53/X sky130_fd_sc_hd__dlygate4sd3_1
Xhold42 hold42/A VGND VGND VPWR VPWR hold42/X sky130_fd_sc_hd__dlygate4sd3_1
Xhold97 hold97/A VGND VGND VPWR VPWR hold97/X sky130_fd_sc_hd__dlygate4sd3_1
XFILLER_75_279 VGND VGND VPWR VPWR sky130_fd_sc_hd__fill_1
Xhold86 hold86/A VGND VGND VPWR VPWR hold86/X sky130_fd_sc_hd__dlygate4sd3_1
XTAP_TAPCELL_ROW_3_261 VGND VPWR sky130_fd_sc_hd__tapvpwrvgnd_1
Xhold75 hold75/A VGND VGND VPWR VPWR hold75/X sky130_fd_sc_hd__dlygate4sd3_1
XPHY_EDGE_ROW_51_Left_159 VGND VGND VPWR VPWR sky130_fd_sc_hd__decap_3
XTAP_TAPCELL_ROW_100_1336 VGND VPWR sky130_fd_sc_hd__tapvpwrvgnd_1
XFILLER_61_51 VGND VGND VPWR VPWR sky130_fd_sc_hd__decap_4
XFILLER_8_501 VGND VGND VPWR VPWR sky130_fd_sc_hd__decap_3
XFILLER_8_589 VGND VGND VPWR VPWR sky130_fd_sc_hd__decap_8
XFILLER_79_541 VPWR VGND VPWR VGND sky130_ef_sc_hd__decap_12
XPHY_EDGE_ROW_60_Left_168 VGND VGND VPWR VPWR sky130_fd_sc_hd__decap_3
XFILLER_79_585 VPWR VGND VPWR VGND sky130_ef_sc_hd__decap_12
X_3170_ _3128_/A _3128_/B _3151_/A _3169_/Y VGND VGND VPWR VPWR _3171_/B sky130_fd_sc_hd__a31o_1
XFILLER_94_533 VPWR VGND VPWR VGND sky130_ef_sc_hd__decap_12
XTAP_TAPCELL_ROW_65_948 VGND VPWR sky130_fd_sc_hd__tapvpwrvgnd_1
XTAP_TAPCELL_ROW_37_639 VGND VPWR sky130_fd_sc_hd__tapvpwrvgnd_1
XFILLER_47_460 VGND VGND VPWR VPWR sky130_fd_sc_hd__fill_1
X_2954_ _2954_/A VGND VGND VPWR VPWR _3028_/B sky130_fd_sc_hd__inv_2
X_2885_ _4751_/Q _2885_/B VGND VGND VPWR VPWR _2886_/B sky130_fd_sc_hd__nand2_1
X_4624_ _4656_/CLK _4624_/D fanout120/X VGND VGND VPWR VPWR _4624_/Q sky130_fd_sc_hd__dfrtp_1
XPHY_EDGE_ROW_6_Right_6 VGND VGND VPWR VPWR sky130_fd_sc_hd__decap_3
X_4555_ _4735_/CLK _4555_/D fanout149/X VGND VGND VPWR VPWR _4555_/Q sky130_fd_sc_hd__dfrtp_1
X_3506_ _3506_/A _3506_/B VGND VGND VPWR VPWR _3507_/B sky130_fd_sc_hd__xor2_1
XFILLER_89_305 VGND VGND VPWR VPWR sky130_fd_sc_hd__decap_8
XTAP_TAPCELL_ROW_77_1084 VGND VPWR sky130_fd_sc_hd__tapvpwrvgnd_1
X_4486_ _4735_/CLK _4486_/D fanout149/X VGND VGND VPWR VPWR _4486_/Q sky130_fd_sc_hd__dfrtp_1
XFILLER_103_137 VPWR VGND VPWR VGND sky130_ef_sc_hd__decap_12
X_3437_ _3420_/B _3422_/B _3418_/X VGND VGND VPWR VPWR _3442_/A sky130_fd_sc_hd__a21o_1
X_3368_ _3451_/A _3368_/B _3368_/C VGND VGND VPWR VPWR _3378_/B sky130_fd_sc_hd__and3_1
XFILLER_97_393 VPWR VGND VPWR VGND sky130_ef_sc_hd__decap_12
XFILLER_66_29 VPWR VGND VPWR VGND sky130_ef_sc_hd__decap_12
X_2319_ _2319_/A _2319_/B _2319_/C _2319_/D VGND VGND VPWR VPWR _2320_/C sky130_fd_sc_hd__or4_1
X_3299_ _3554_/B2 _3297_/X _3298_/Y _3470_/B2 _4523_/Q VGND VGND VPWR VPWR _4523_/D
+ sky130_fd_sc_hd__a32o_1
XFILLER_57_268 VPWR VGND VPWR VGND sky130_ef_sc_hd__decap_12
XTAP_TAPCELL_ROW_0_220 VGND VPWR sky130_fd_sc_hd__tapvpwrvgnd_1
XTAP_TAPCELL_ROW_0_231 VGND VPWR sky130_fd_sc_hd__tapvpwrvgnd_1
XFILLER_15_55 VGND VGND VPWR VPWR sky130_fd_sc_hd__fill_1
XFILLER_41_636 VGND VGND VPWR VPWR sky130_fd_sc_hd__fill_1
XFILLER_107_421 VPWR VGND VPWR VGND sky130_ef_sc_hd__decap_12
XFILLER_5_559 VGND VGND VPWR VPWR sky130_fd_sc_hd__fill_1
XFILLER_31_98 VGND VGND VPWR VPWR sky130_fd_sc_hd__decap_6
XTAP_TAPCELL_ROW_8_320 VGND VPWR sky130_fd_sc_hd__tapvpwrvgnd_1
XFILLER_0_253 VPWR VGND VPWR VGND sky130_ef_sc_hd__decap_12
XFILLER_76_533 VPWR VGND VPWR VGND sky130_ef_sc_hd__decap_12
XFILLER_48_224 VGND VGND VPWR VPWR sky130_fd_sc_hd__fill_2
XFILLER_91_503 VGND VGND VPWR VPWR sky130_fd_sc_hd__fill_1
XFILLER_36_419 VGND VGND VPWR VPWR sky130_fd_sc_hd__fill_1
XFILLER_56_290 VPWR VGND VPWR VGND sky130_ef_sc_hd__decap_12
XTAP_TAPCELL_ROW_62_918 VGND VPWR sky130_fd_sc_hd__tapvpwrvgnd_1
XTAP_TAPCELL_ROW_34_609 VGND VPWR sky130_fd_sc_hd__tapvpwrvgnd_1
XFILLER_31_113 VGND VGND VPWR VPWR sky130_fd_sc_hd__decap_6
XFILLER_72_83 VGND VGND VPWR VPWR sky130_fd_sc_hd__fill_1
XPHY_EDGE_ROW_59_Right_59 VGND VGND VPWR VPWR sky130_fd_sc_hd__decap_3
XTAP_TAPCELL_ROW_14_388 VGND VPWR sky130_fd_sc_hd__tapvpwrvgnd_1
XTAP_TAPCELL_ROW_42_697 VGND VPWR sky130_fd_sc_hd__tapvpwrvgnd_1
XFILLER_8_342 VGND VGND VPWR VPWR sky130_fd_sc_hd__fill_2
X_2670_ _4742_/Q _2672_/B VGND VGND VPWR VPWR _2670_/Y sky130_fd_sc_hd__nand2_1
X_4340_ _4752_/Q _4345_/A2 _3620_/A _4345_/B2 VGND VGND VPWR VPWR _4752_/D sky130_fd_sc_hd__a22o_1
X_4271_ _4271_/A VGND VGND VPWR VPWR _4271_/Y sky130_fd_sc_hd__inv_2
X_3222_ _3222_/A _3222_/B VGND VGND VPWR VPWR _3224_/B sky130_fd_sc_hd__xnor2_1
X_3153_ hold250/X _4355_/A2 _3947_/A _4354_/B2 VGND VGND VPWR VPWR _4515_/D sky130_fd_sc_hd__a22o_1
XPHY_EDGE_ROW_68_Right_68 VGND VGND VPWR VPWR sky130_fd_sc_hd__decap_3
XFILLER_82_525 VGND VGND VPWR VPWR sky130_fd_sc_hd__decap_6
X_3084_ _4759_/Q _3084_/B VGND VGND VPWR VPWR _3085_/B sky130_fd_sc_hd__or2_1
XFILLER_82_569 VPWR VGND VPWR VGND sky130_ef_sc_hd__decap_12
XFILLER_22_113 VGND VGND VPWR VPWR sky130_fd_sc_hd__decap_8
X_3986_ hold4/A _3986_/B VGND VGND VPWR VPWR _3987_/B sky130_fd_sc_hd__xnor2_1
XPHY_EDGE_ROW_77_Right_77 VGND VGND VPWR VPWR sky130_fd_sc_hd__decap_3
XFILLER_50_455 VGND VGND VPWR VPWR sky130_fd_sc_hd__fill_1
XFILLER_22_168 VGND VGND VPWR VPWR sky130_fd_sc_hd__fill_1
XFILLER_50_477 VGND VGND VPWR VPWR sky130_fd_sc_hd__decap_4
X_2937_ _4753_/Q _2938_/B VGND VGND VPWR VPWR _2937_/Y sky130_fd_sc_hd__nor2_1
XTAP_TAPCELL_ROW_79_1102 VGND VPWR sky130_fd_sc_hd__tapvpwrvgnd_1
XPHY_EDGE_ROW_107_Left_215 VGND VGND VPWR VPWR sky130_fd_sc_hd__decap_3
X_4607_ _4676_/CLK _4607_/D fanout134/X VGND VGND VPWR VPWR _4607_/Q sky130_fd_sc_hd__dfrtp_1
X_2868_ _4536_/Q _2868_/B VGND VGND VPWR VPWR _2869_/B sky130_fd_sc_hd__or2_1
X_2799_ _4501_/Q _2799_/B VGND VGND VPWR VPWR _2831_/C sky130_fd_sc_hd__xnor2_4
XFILLER_104_413 VGND VGND VPWR VPWR sky130_fd_sc_hd__decap_6
X_4538_ _4538_/CLK _4538_/D fanout167/X VGND VGND VPWR VPWR _4538_/Q sky130_fd_sc_hd__dfrtp_4
X_4469_ _4716_/CLK _4469_/D fanout165/X VGND VGND VPWR VPWR _4469_/Q sky130_fd_sc_hd__dfrtp_1
XFILLER_104_457 VPWR VGND VPWR VGND sky130_ef_sc_hd__decap_12
XFILLER_89_179 VGND VGND VPWR VPWR sky130_fd_sc_hd__decap_4
XPHY_EDGE_ROW_86_Right_86 VGND VGND VPWR VPWR sky130_fd_sc_hd__decap_3
XFILLER_77_39 VPWR VGND VPWR VGND sky130_ef_sc_hd__decap_12
XFILLER_58_533 VPWR VGND VPWR VGND sky130_ef_sc_hd__decap_12
XFILLER_93_27 VPWR VGND VPWR VGND sky130_ef_sc_hd__decap_12
XFILLER_73_503 VGND VGND VPWR VPWR sky130_fd_sc_hd__fill_1
XFILLER_26_65 VPWR VGND VPWR VGND sky130_ef_sc_hd__decap_12
XFILLER_26_441 VGND VGND VPWR VPWR sky130_fd_sc_hd__fill_2
XFILLER_26_474 VGND VGND VPWR VPWR sky130_fd_sc_hd__fill_2
XPHY_EDGE_ROW_95_Right_95 VGND VGND VPWR VPWR sky130_fd_sc_hd__decap_3
XFILLER_9_139 VGND VGND VPWR VPWR sky130_fd_sc_hd__fill_1
XFILLER_42_53 VPWR VGND VPWR VGND sky130_ef_sc_hd__decap_12
XTAP_TAPCELL_ROW_11_358 VGND VPWR sky130_fd_sc_hd__tapvpwrvgnd_1
XFILLER_95_105 VGND VGND VPWR VPWR sky130_fd_sc_hd__decap_6
XFILLER_1_573 VPWR VGND VPWR VGND sky130_ef_sc_hd__decap_12
XFILLER_3_69 VPWR VGND VPWR VGND sky130_ef_sc_hd__decap_12
XFILLER_95_149 VPWR VGND VPWR VGND sky130_ef_sc_hd__decap_12
XFILLER_64_525 VGND VGND VPWR VPWR sky130_fd_sc_hd__decap_6
XFILLER_64_569 VPWR VGND VPWR VGND sky130_ef_sc_hd__decap_12
XTAP_TAPCELL_ROW_19_436 VGND VPWR sky130_fd_sc_hd__tapvpwrvgnd_1
XTAP_TAPCELL_ROW_47_745 VGND VPWR sky130_fd_sc_hd__tapvpwrvgnd_1
XFILLER_17_474 VGND VGND VPWR VPWR sky130_fd_sc_hd__fill_2
XFILLER_32_433 VPWR VGND VPWR VGND sky130_ef_sc_hd__decap_12
XTAP_TAPCELL_ROW_106_1397 VGND VPWR sky130_fd_sc_hd__tapvpwrvgnd_1
X_3840_ _3769_/A _3767_/A _3766_/Y _3839_/D VGND VGND VPWR VPWR _3843_/C sky130_fd_sc_hd__o211a_1
X_3771_ _4758_/Q _3800_/C VGND VGND VPWR VPWR _3774_/A sky130_fd_sc_hd__xor2_1
XFILLER_32_477 VGND VGND VPWR VPWR sky130_fd_sc_hd__decap_8
X_2722_ _4526_/Q _4535_/Q VGND VGND VPWR VPWR _2723_/B sky130_fd_sc_hd__xor2_2
XFILLER_73_3 VPWR VGND VPWR VGND sky130_ef_sc_hd__decap_12
X_2653_ _2673_/B _2653_/B VGND VGND VPWR VPWR _2711_/B sky130_fd_sc_hd__or2_1
X_2584_ _2584_/A _2584_/B VGND VGND VPWR VPWR _2585_/B sky130_fd_sc_hd__xor2_1
XTAP_TAPCELL_ROW_74_1043 VGND VPWR sky130_fd_sc_hd__tapvpwrvgnd_1
X_4323_ uo_out[7] _4322_/Y _4323_/S VGND VGND VPWR VPWR _4726_/D sky130_fd_sc_hd__mux2_1
XFILLER_101_405 VPWR VGND VPWR VGND sky130_ef_sc_hd__decap_12
XFILLER_87_617 VPWR VGND VPWR VGND sky130_ef_sc_hd__decap_12
Xfanout129 fanout132/X VGND VGND VPWR VPWR fanout129/X sky130_fd_sc_hd__buf_4
Xfanout107 hold2/A VGND VGND VPWR VPWR _3536_/A sky130_fd_sc_hd__buf_2
Xfanout118 _4360_/Q VGND VGND VPWR VPWR _4131_/D sky130_fd_sc_hd__clkbuf_2
X_4254_ _4713_/Q _4712_/Q _4254_/C VGND VGND VPWR VPWR _4259_/B sky130_fd_sc_hd__and3_1
XFILLER_101_449 VPWR VGND VPWR VGND sky130_ef_sc_hd__decap_12
X_3205_ _4518_/Q _3207_/B VGND VGND VPWR VPWR _3205_/X sky130_fd_sc_hd__and2_1
X_4185_ _4692_/Q _4183_/C _4693_/Q VGND VGND VPWR VPWR _4185_/X sky130_fd_sc_hd__a21o_1
XFILLER_103_15 VPWR VGND VPWR VGND sky130_ef_sc_hd__decap_12
X_3136_ _3137_/A _3137_/B VGND VGND VPWR VPWR _3159_/B sky130_fd_sc_hd__nand2b_1
X_3067_ _3791_/A _3067_/B VGND VGND VPWR VPWR _3068_/B sky130_fd_sc_hd__or2_1
XFILLER_55_547 VPWR VGND VPWR VGND sky130_ef_sc_hd__decap_12
XFILLER_82_377 VGND VGND VPWR VPWR sky130_fd_sc_hd__decap_6
XTAP_TAPCELL_ROW_85_1172 VGND VPWR sky130_fd_sc_hd__tapvpwrvgnd_1
X_3969_ _3946_/Y _3950_/B _3948_/B VGND VGND VPWR VPWR _3970_/B sky130_fd_sc_hd__o21ai_1
XFILLER_88_27 VGND VGND VPWR VPWR sky130_fd_sc_hd__fill_1
XFILLER_104_221 VPWR VGND VPWR VGND sky130_ef_sc_hd__decap_12
XTAP_TAPCELL_ROW_96_1290 VGND VPWR sky130_fd_sc_hd__tapvpwrvgnd_1
Xhold150 _4642_/Q VGND VGND VPWR VPWR hold150/X sky130_fd_sc_hd__dlygate4sd3_1
Xhold161 _4564_/Q VGND VGND VPWR VPWR hold161/X sky130_fd_sc_hd__dlygate4sd3_1
XFILLER_104_265 VPWR VGND VPWR VGND sky130_ef_sc_hd__decap_12
Xhold183 _4593_/Q VGND VGND VPWR VPWR hold183/X sky130_fd_sc_hd__dlygate4sd3_1
Xhold194 _4659_/Q VGND VGND VPWR VPWR hold194/X sky130_fd_sc_hd__dlygate4sd3_1
Xhold172 _4434_/Q VGND VGND VPWR VPWR hold172/X sky130_fd_sc_hd__dlygate4sd3_1
XFILLER_93_609 VGND VGND VPWR VPWR sky130_fd_sc_hd__decap_6
XFILLER_18_238 VPWR VGND VPWR VGND sky130_ef_sc_hd__decap_12
XFILLER_73_377 VGND VGND VPWR VPWR sky130_fd_sc_hd__fill_2
XFILLER_61_517 VPWR VGND VPWR VGND sky130_ef_sc_hd__decap_12
XTAP_TAPCELL_ROW_16_406 VGND VPWR sky130_fd_sc_hd__tapvpwrvgnd_1
XTAP_TAPCELL_ROW_44_715 VGND VPWR sky130_fd_sc_hd__tapvpwrvgnd_1
XFILLER_14_477 VGND VGND VPWR VPWR sky130_fd_sc_hd__decap_6
XFILLER_14_466 VGND VGND VPWR VPWR sky130_fd_sc_hd__fill_1
XTAP_TAPCELL_ROW_99_1319 VGND VPWR sky130_fd_sc_hd__tapvpwrvgnd_1
XTAP_TAPCELL_ROW_24_494 VGND VPWR sky130_fd_sc_hd__tapvpwrvgnd_1
XFILLER_69_617 VPWR VGND VPWR VGND sky130_ef_sc_hd__decap_12
XFILLER_96_469 VGND VGND VPWR VPWR sky130_fd_sc_hd__decap_6
XFILLER_37_503 VGND VGND VPWR VPWR sky130_fd_sc_hd__fill_1
XFILLER_37_569 VGND VGND VPWR VPWR sky130_fd_sc_hd__decap_3
X_3823_ _3856_/B _3823_/B VGND VGND VPWR VPWR _3834_/A sky130_fd_sc_hd__nand2_1
X_3754_ _3785_/A _3754_/B VGND VGND VPWR VPWR _3761_/A sky130_fd_sc_hd__or2_1
XFILLER_9_470 VGND VGND VPWR VPWR sky130_fd_sc_hd__decap_4
X_3685_ _4540_/Q _3718_/B VGND VGND VPWR VPWR _3687_/A sky130_fd_sc_hd__and2_1
X_2705_ _4497_/Q _2705_/B VGND VGND VPWR VPWR _2706_/B sky130_fd_sc_hd__or2_1
X_2636_ _4526_/Q _2636_/B VGND VGND VPWR VPWR _2637_/B sky130_fd_sc_hd__or2_1
X_2567_ _4557_/Q _4589_/Q _4621_/Q _4653_/Q _3257_/A _3278_/B VGND VGND VPWR VPWR
+ _2569_/B sky130_fd_sc_hd__mux4_1
X_2498_ _2498_/A _2498_/B VGND VGND VPWR VPWR _2498_/Y sky130_fd_sc_hd__nor2_1
X_4306_ _4306_/A VGND VGND VPWR VPWR _4306_/Y sky130_fd_sc_hd__inv_2
XFILLER_75_609 VGND VGND VPWR VPWR sky130_fd_sc_hd__decap_6
X_4237_ _4707_/Q _4706_/Q _4229_/B _4708_/Q VGND VGND VPWR VPWR _4237_/X sky130_fd_sc_hd__a31o_1
XFILLER_101_279 VGND VGND VPWR VPWR sky130_fd_sc_hd__fill_1
XFILLER_74_29 VPWR VGND VPWR VGND sky130_ef_sc_hd__decap_12
X_4168_ _4206_/A1 _4166_/Y _4167_/X _4206_/B1 hold263/X VGND VGND VPWR VPWR _4688_/D
+ sky130_fd_sc_hd__a32o_1
X_3119_ _3836_/A _3119_/B VGND VGND VPWR VPWR _3120_/B sky130_fd_sc_hd__nor2_1
X_4099_ _4013_/B _4016_/B _4135_/A1 _4094_/Y hold64/X VGND VGND VPWR VPWR _4632_/D
+ sky130_fd_sc_hd__a32o_1
XFILLER_15_219 VGND VGND VPWR VPWR sky130_fd_sc_hd__decap_4
XFILLER_51_561 VPWR VGND VPWR VGND sky130_ef_sc_hd__decap_12
XFILLER_23_55 VGND VGND VPWR VPWR sky130_fd_sc_hd__fill_1
XFILLER_7_418 VGND VGND VPWR VPWR sky130_fd_sc_hd__fill_1
XFILLER_99_15 VPWR VGND VPWR VGND sky130_ef_sc_hd__decap_12
XTAP_TAPCELL_ROW_21_464 VGND VPWR sky130_fd_sc_hd__tapvpwrvgnd_1
XFILLER_105_541 VPWR VGND VPWR VGND sky130_ef_sc_hd__decap_12
XFILLER_3_3 VPWR VGND VPWR VGND sky130_ef_sc_hd__decap_12
XFILLER_105_585 VPWR VGND VPWR VGND sky130_ef_sc_hd__decap_12
XFILLER_2_167 VGND VGND VPWR VPWR sky130_fd_sc_hd__fill_2
XFILLER_2_178 VPWR VGND VPWR VGND sky130_ef_sc_hd__decap_12
XFILLER_48_41 VPWR VGND VPWR VGND sky130_ef_sc_hd__decap_12
XFILLER_93_417 VPWR VGND VPWR VGND sky130_ef_sc_hd__decap_12
XFILLER_0_26 VGND VGND VPWR VPWR sky130_fd_sc_hd__fill_2
XTAP_TAPCELL_ROW_29_553 VGND VPWR sky130_fd_sc_hd__tapvpwrvgnd_1
XTAP_TAPCELL_ROW_57_862 VGND VPWR sky130_fd_sc_hd__tapvpwrvgnd_1
XFILLER_46_377 VPWR VGND VPWR VGND sky130_ef_sc_hd__decap_12
XTAP_TAPCELL_ROW_103_1367 VGND VPWR sky130_fd_sc_hd__tapvpwrvgnd_1
XFILLER_42_550 VGND VGND VPWR VPWR sky130_fd_sc_hd__decap_4
XFILLER_42_583 VGND VGND VPWR VPWR sky130_fd_sc_hd__decap_4
XFILLER_14_296 VPWR VGND VPWR VGND sky130_ef_sc_hd__decap_12
XFILLER_9_57 VPWR VGND VPWR VGND sky130_ef_sc_hd__decap_12
XFILLER_80_83 VGND VGND VPWR VPWR sky130_fd_sc_hd__fill_1
X_3470_ _3466_/Y _3469_/X _4531_/Q _3470_/B2 VGND VGND VPWR VPWR _4531_/D sky130_fd_sc_hd__a2bb2o_1
X_2421_ _2431_/A _4368_/Q _4365_/Q _2258_/A VGND VGND VPWR VPWR _2422_/B sky130_fd_sc_hd__o31ai_2
X_2352_ _2352_/A _2352_/B VGND VGND VPWR VPWR _4363_/D sky130_fd_sc_hd__nand2_1
XTAP_TAPCELL_ROW_71_1013 VGND VPWR sky130_fd_sc_hd__tapvpwrvgnd_1
XFILLER_69_414 VGND VGND VPWR VPWR sky130_fd_sc_hd__decap_4
XFILLER_36_3 VPWR VGND VPWR VGND sky130_ef_sc_hd__decap_12
XFILLER_96_233 VPWR VGND VPWR VGND sky130_ef_sc_hd__decap_12
XFILLER_69_469 VPWR VGND VPWR VGND sky130_ef_sc_hd__decap_12
X_2283_ _4215_/A _4458_/Q _2281_/X VGND VGND VPWR VPWR _2283_/Y sky130_fd_sc_hd__a21oi_1
XFILLER_57_609 VGND VGND VPWR VPWR sky130_fd_sc_hd__decap_6
XFILLER_96_277 VPWR VGND VPWR VGND sky130_ef_sc_hd__decap_12
X_4022_ _4731_/Q _4030_/B VGND VGND VPWR VPWR _4022_/X sky130_fd_sc_hd__and2_2
XFILLER_80_601 VPWR VGND VPWR VGND sky130_ef_sc_hd__decap_12
XFILLER_64_141 VGND VGND VPWR VPWR sky130_fd_sc_hd__decap_4
XFILLER_25_517 VPWR VGND VPWR VGND sky130_ef_sc_hd__decap_12
XTAP_TAPCELL_ROW_82_1131 VGND VPWR sky130_fd_sc_hd__tapvpwrvgnd_1
XFILLER_100_27 VGND VGND VPWR VPWR sky130_fd_sc_hd__fill_1
X_3806_ _3806_/A _3822_/A VGND VGND VPWR VPWR _3820_/B sky130_fd_sc_hd__and2_1
X_4786_ _4786_/A VGND VGND VPWR VPWR uio_out[2] sky130_fd_sc_hd__buf_2
XFILLER_20_266 VGND VGND VPWR VPWR sky130_fd_sc_hd__fill_2
X_3737_ _3737_/A _3860_/A VGND VGND VPWR VPWR _3738_/B sky130_fd_sc_hd__xnor2_2
X_3668_ _3723_/C _3668_/B VGND VGND VPWR VPWR _3720_/A sky130_fd_sc_hd__and2_1
XTAP_TAPCELL_ROW_93_1260 VGND VPWR sky130_fd_sc_hd__tapvpwrvgnd_1
X_2619_ _4493_/Q _2620_/B VGND VGND VPWR VPWR _2619_/X sky130_fd_sc_hd__and2_1
X_3599_ hold62/A hold47/A hold93/A _4604_/Q _3599_/S0 _3519_/S VGND VGND VPWR VPWR
+ _3601_/B sky130_fd_sc_hd__mux4_1
XFILLER_102_533 VPWR VGND VPWR VGND sky130_ef_sc_hd__decap_12
XFILLER_87_277 VGND VGND VPWR VPWR sky130_fd_sc_hd__decap_3
XFILLER_85_39 VPWR VGND VPWR VGND sky130_ef_sc_hd__decap_12
XFILLER_83_461 VPWR VGND VPWR VGND sky130_ef_sc_hd__decap_12
XFILLER_18_77 VGND VGND VPWR VPWR sky130_fd_sc_hd__decap_6
XFILLER_16_517 VGND VGND VPWR VPWR sky130_fd_sc_hd__decap_4
XTAP_TAPCELL_ROW_54_821 VGND VPWR sky130_fd_sc_hd__tapvpwrvgnd_1
XFILLER_55_163 VGND VGND VPWR VPWR sky130_fd_sc_hd__decap_4
XTAP_TAPCELL_ROW_26_523 VGND VPWR sky130_fd_sc_hd__tapvpwrvgnd_1
XFILLER_31_509 VGND VGND VPWR VPWR sky130_fd_sc_hd__decap_4
XFILLER_11_266 VGND VGND VPWR VPWR sky130_fd_sc_hd__fill_1
XFILLER_11_277 VGND VGND VPWR VPWR sky130_fd_sc_hd__decap_3
XFILLER_50_53 VPWR VGND VPWR VGND sky130_ef_sc_hd__decap_12
XFILLER_59_51 VGND VGND VPWR VPWR sky130_fd_sc_hd__decap_4
XFILLER_105_393 VPWR VGND VPWR VGND sky130_ef_sc_hd__decap_12
XFILLER_93_225 VPWR VGND VPWR VGND sky130_ef_sc_hd__decap_12
XFILLER_78_299 VGND VGND VPWR VPWR sky130_fd_sc_hd__decap_3
XFILLER_66_439 VGND VGND VPWR VPWR sky130_fd_sc_hd__decap_6
XFILLER_19_322 VGND VGND VPWR VPWR sky130_fd_sc_hd__decap_6
XFILLER_62_601 VPWR VGND VPWR VGND sky130_ef_sc_hd__decap_12
XFILLER_19_377 VPWR VGND VPWR VGND sky130_ef_sc_hd__decap_12
XFILLER_34_358 VGND VGND VPWR VPWR sky130_fd_sc_hd__decap_6
XFILLER_15_561 VGND VGND VPWR VPWR sky130_fd_sc_hd__decap_8
XFILLER_15_572 VGND VGND VPWR VPWR sky130_fd_sc_hd__fill_1
X_2970_ _4540_/Q _2970_/B VGND VGND VPWR VPWR _2971_/B sky130_fd_sc_hd__or2_1
X_4640_ _4676_/CLK _4640_/D fanout133/X VGND VGND VPWR VPWR _4640_/Q sky130_fd_sc_hd__dfrtp_1
X_4571_ clkload8/A _4571_/D fanout125/X VGND VGND VPWR VPWR hold77/A sky130_fd_sc_hd__dfrtp_1
XFILLER_6_270 VGND VGND VPWR VPWR sky130_fd_sc_hd__decap_6
X_3522_ _4601_/Q _3522_/B VGND VGND VPWR VPWR _3522_/Y sky130_fd_sc_hd__nand2_1
X_3453_ _3541_/A _3453_/B VGND VGND VPWR VPWR _3525_/C sky130_fd_sc_hd__nand2_1
X_2404_ hold8/X _2407_/A2 _2407_/B1 _4505_/Q VGND VGND VPWR VPWR hold9/A sky130_fd_sc_hd__a22o_1
XFILLER_97_553 VGND VGND VPWR VPWR sky130_fd_sc_hd__decap_6
XFILLER_69_244 VGND VGND VPWR VPWR sky130_fd_sc_hd__decap_3
XFILLER_69_222 VGND VGND VPWR VPWR sky130_fd_sc_hd__fill_2
X_3384_ _3382_/X _3383_/Y _3363_/X VGND VGND VPWR VPWR _3384_/Y sky130_fd_sc_hd__a21oi_1
X_2335_ input8/X _4718_/D VGND VGND VPWR VPWR _4734_/D sky130_fd_sc_hd__and2_1
XFILLER_97_597 VPWR VGND VPWR VGND sky130_ef_sc_hd__decap_12
XFILLER_84_225 VGND VGND VPWR VPWR sky130_fd_sc_hd__fill_2
XFILLER_29_119 VGND VGND VPWR VPWR sky130_fd_sc_hd__fill_1
XFILLER_38_631 VGND VGND VPWR VPWR sky130_fd_sc_hd__decap_6
X_2266_ _4712_/Q _2521_/A VGND VGND VPWR VPWR _2271_/B sky130_fd_sc_hd__nor2_1
XTAP_TAPCELL_ROW_68_979 VGND VPWR sky130_fd_sc_hd__tapvpwrvgnd_1
X_4005_ hold130/X _4733_/Q _4007_/S VGND VGND VPWR VPWR _4562_/D sky130_fd_sc_hd__mux2_1
X_2197_ _4716_/Q VGND VGND VPWR VPWR _4265_/A sky130_fd_sc_hd__inv_2
XFILLER_65_461 VPWR VGND VPWR VGND sky130_ef_sc_hd__decap_12
XFILLER_52_177 VGND VGND VPWR VPWR sky130_fd_sc_hd__decap_8
XTAP_TAPCELL_ROW_31_570 VGND VPWR sky130_fd_sc_hd__tapvpwrvgnd_1
X_4769_ _4770_/CLK _4769_/D fanout162/X VGND VGND VPWR VPWR _4769_/Q sky130_fd_sc_hd__dfrtp_1
XFILLER_4_207 VGND VGND VPWR VPWR sky130_fd_sc_hd__fill_1
XFILLER_96_27 VGND VGND VPWR VPWR sky130_fd_sc_hd__fill_1
XFILLER_88_531 VGND VGND VPWR VPWR sky130_fd_sc_hd__fill_1
XFILLER_102_363 VGND VGND VPWR VPWR sky130_fd_sc_hd__fill_1
Xhold10 hold10/A VGND VGND VPWR VPWR hold10/X sky130_fd_sc_hd__dlygate4sd3_1
Xhold21 hold21/A VGND VGND VPWR VPWR hold21/X sky130_fd_sc_hd__dlygate4sd3_1
Xhold32 hold32/A VGND VGND VPWR VPWR hold32/X sky130_fd_sc_hd__dlygate4sd3_1
Xhold65 hold65/A VGND VGND VPWR VPWR hold65/X sky130_fd_sc_hd__dlygate4sd3_1
Xhold54 hold54/A VGND VGND VPWR VPWR hold54/X sky130_fd_sc_hd__dlygate4sd3_1
XFILLER_75_225 VGND VGND VPWR VPWR sky130_fd_sc_hd__decap_4
Xhold43 hold43/A VGND VGND VPWR VPWR hold43/X sky130_fd_sc_hd__dlygate4sd3_1
Xhold76 hold76/A VGND VGND VPWR VPWR hold76/X sky130_fd_sc_hd__dlygate4sd3_1
Xhold98 hold98/A VGND VGND VPWR VPWR hold98/X sky130_fd_sc_hd__dlygate4sd3_1
Xhold87 hold87/A VGND VGND VPWR VPWR hold87/X sky130_fd_sc_hd__dlygate4sd3_1
XTAP_TAPCELL_ROW_3_262 VGND VPWR sky130_fd_sc_hd__tapvpwrvgnd_1
XFILLER_28_174 VGND VGND VPWR VPWR sky130_fd_sc_hd__fill_1
XFILLER_28_185 VGND VGND VPWR VPWR sky130_fd_sc_hd__decap_6
XFILLER_16_369 VGND VGND VPWR VPWR sky130_fd_sc_hd__fill_1
XFILLER_43_177 VPWR VGND VPWR VGND sky130_ef_sc_hd__decap_12
XFILLER_101_81 VPWR VGND VPWR VGND sky130_ef_sc_hd__decap_12
XTAP_TAPCELL_ROW_100_1337 VGND VPWR sky130_fd_sc_hd__tapvpwrvgnd_1
XFILLER_24_391 VPWR VGND VPWR VGND sky130_ef_sc_hd__decap_12
XFILLER_94_501 VPWR VGND VPWR VGND sky130_ef_sc_hd__decap_12
XFILLER_79_553 VGND VGND VPWR VPWR sky130_fd_sc_hd__decap_6
XFILLER_39_406 VGND VGND VPWR VPWR sky130_fd_sc_hd__fill_1
XFILLER_94_545 VPWR VGND VPWR VGND sky130_ef_sc_hd__decap_12
XFILLER_79_597 VPWR VGND VPWR VGND sky130_ef_sc_hd__decap_12
XFILLER_66_269 VGND VGND VPWR VPWR sky130_fd_sc_hd__decap_4
XFILLER_94_589 VPWR VGND VPWR VGND sky130_ef_sc_hd__decap_12
XTAP_TAPCELL_ROW_65_949 VGND VPWR sky130_fd_sc_hd__tapvpwrvgnd_1
XFILLER_34_155 VGND VGND VPWR VPWR sky130_fd_sc_hd__decap_6
X_2953_ _2953_/A _2953_/B VGND VGND VPWR VPWR _2954_/A sky130_fd_sc_hd__nor2_1
X_2884_ _4751_/Q _2885_/B VGND VGND VPWR VPWR _2884_/Y sky130_fd_sc_hd__nor2_1
X_4623_ _4737_/CLK _4623_/D fanout122/X VGND VGND VPWR VPWR _4623_/Q sky130_fd_sc_hd__dfrtp_1
X_4554_ _4735_/CLK _4554_/D fanout149/X VGND VGND VPWR VPWR _4554_/Q sky130_fd_sc_hd__dfrtp_1
X_3505_ _3517_/A _3516_/B VGND VGND VPWR VPWR _3506_/B sky130_fd_sc_hd__nand2_1
XFILLER_103_105 VGND VGND VPWR VPWR sky130_fd_sc_hd__decap_6
XTAP_TAPCELL_ROW_77_1074 VGND VPWR sky130_fd_sc_hd__tapvpwrvgnd_1
X_4485_ _4531_/CLK _4485_/D fanout148/X VGND VGND VPWR VPWR _4485_/Q sky130_fd_sc_hd__dfrtp_1
XFILLER_106_15 VPWR VGND VPWR VGND sky130_ef_sc_hd__decap_12
XFILLER_103_149 VPWR VGND VPWR VGND sky130_ef_sc_hd__decap_12
X_3436_ _3436_/A _3436_/B VGND VGND VPWR VPWR _3443_/A sky130_fd_sc_hd__xnor2_1
XFILLER_97_361 VPWR VGND VPWR VGND sky130_ef_sc_hd__decap_12
X_3367_ _3368_/B _3368_/C _3451_/A VGND VGND VPWR VPWR _3378_/A sky130_fd_sc_hd__a21oi_1
X_2318_ _4713_/Q _2203_/Y _4240_/A _4465_/Q _2262_/Y VGND VGND VPWR VPWR _2319_/D
+ sky130_fd_sc_hd__a221o_1
X_3298_ _3298_/A _3298_/B VGND VGND VPWR VPWR _3298_/Y sky130_fd_sc_hd__nand2_1
XTAP_TAPCELL_ROW_0_221 VGND VPWR sky130_fd_sc_hd__tapvpwrvgnd_1
X_2249_ _2427_/A _2249_/B _4283_/A VGND VGND VPWR VPWR _2250_/B sky130_fd_sc_hd__and3_1
XFILLER_82_29 VPWR VGND VPWR VGND sky130_ef_sc_hd__decap_12
XTAP_TAPCELL_ROW_0_232 VGND VPWR sky130_fd_sc_hd__tapvpwrvgnd_1
XFILLER_41_615 VGND VGND VPWR VPWR sky130_fd_sc_hd__fill_1
XFILLER_80_272 VGND VGND VPWR VPWR sky130_fd_sc_hd__decap_8
XFILLER_15_89 VGND VGND VPWR VPWR sky130_fd_sc_hd__decap_3
XFILLER_40_147 VGND VGND VPWR VPWR sky130_fd_sc_hd__fill_1
XFILLER_31_55 VGND VGND VPWR VPWR sky130_fd_sc_hd__fill_1
XFILLER_31_77 VGND VGND VPWR VPWR sky130_fd_sc_hd__fill_1
XFILLER_107_433 VPWR VGND VPWR VGND sky130_ef_sc_hd__decap_12
XFILLER_107_477 VPWR VGND VPWR VGND sky130_ef_sc_hd__decap_12
XFILLER_103_3 VPWR VGND VPWR VGND sky130_ef_sc_hd__decap_12
XTAP_TAPCELL_ROW_8_321 VGND VPWR sky130_fd_sc_hd__tapvpwrvgnd_1
XFILLER_76_501 VPWR VGND VPWR VGND sky130_ef_sc_hd__decap_12
XFILLER_0_265 VPWR VGND VPWR VGND sky130_ef_sc_hd__decap_12
XFILLER_76_545 VPWR VGND VPWR VGND sky130_ef_sc_hd__decap_12
XFILLER_56_41 VPWR VGND VPWR VGND sky130_ef_sc_hd__decap_12
XFILLER_76_589 VPWR VGND VPWR VGND sky130_ef_sc_hd__decap_12
XFILLER_91_559 VGND VGND VPWR VPWR sky130_fd_sc_hd__fill_1
XFILLER_56_85 VGND VGND VPWR VPWR sky130_fd_sc_hd__decap_4
XTAP_TAPCELL_ROW_62_919 VGND VPWR sky130_fd_sc_hd__tapvpwrvgnd_1
XFILLER_71_272 VGND VGND VPWR VPWR sky130_fd_sc_hd__decap_8
XFILLER_44_497 VGND VGND VPWR VPWR sky130_fd_sc_hd__fill_1
XTAP_TAPCELL_ROW_14_389 VGND VPWR sky130_fd_sc_hd__tapvpwrvgnd_1
XFILLER_31_169 VGND VGND VPWR VPWR sky130_fd_sc_hd__decap_8
XTAP_TAPCELL_ROW_42_698 VGND VPWR sky130_fd_sc_hd__tapvpwrvgnd_1
XFILLER_8_365 VGND VGND VPWR VPWR sky130_fd_sc_hd__decap_6
XFILLER_99_615 VGND VGND VPWR VPWR sky130_fd_sc_hd__fill_1
XFILLER_4_593 VGND VGND VPWR VPWR sky130_fd_sc_hd__decap_4
X_4270_ _4404_/Q hold18/A _4420_/Q _4428_/Q _4319_/S0 _2249_/B VGND VGND VPWR VPWR
+ _4271_/A sky130_fd_sc_hd__mux4_1
XFILLER_101_609 VGND VGND VPWR VPWR sky130_fd_sc_hd__decap_6
XFILLER_97_81 VPWR VGND VPWR VGND sky130_ef_sc_hd__decap_12
X_3221_ _3221_/A _3221_/B VGND VGND VPWR VPWR _3222_/B sky130_fd_sc_hd__xnor2_1
XFILLER_86_309 VGND VGND VPWR VPWR sky130_fd_sc_hd__decap_8
XFILLER_79_350 VGND VGND VPWR VPWR sky130_fd_sc_hd__decap_6
XFILLER_67_501 VGND VGND VPWR VPWR sky130_fd_sc_hd__decap_3
X_3152_ _3860_/A VGND VGND VPWR VPWR _3947_/A sky130_fd_sc_hd__inv_2
X_3083_ _4759_/Q _3084_/B VGND VGND VPWR VPWR _3083_/X sky130_fd_sc_hd__and2_1
XFILLER_39_269 VGND VGND VPWR VPWR sky130_fd_sc_hd__decap_8
XFILLER_54_228 VPWR VGND VPWR VGND sky130_ef_sc_hd__decap_12
XFILLER_90_581 VGND VGND VPWR VPWR sky130_fd_sc_hd__decap_6
XFILLER_22_103 VGND VGND VPWR VPWR sky130_fd_sc_hd__fill_1
XFILLER_50_412 VGND VGND VPWR VPWR sky130_fd_sc_hd__decap_4
X_3985_ _3985_/A _3985_/B VGND VGND VPWR VPWR _3986_/B sky130_fd_sc_hd__xnor2_1
X_2936_ _4574_/Q _4606_/Q hold94/A _4670_/Q _4324_/S _3174_/S1 VGND VGND VPWR VPWR
+ _2938_/B sky130_fd_sc_hd__mux4_1
XTAP_TAPCELL_ROW_79_1103 VGND VPWR sky130_fd_sc_hd__tapvpwrvgnd_1
X_2867_ _4536_/Q _2868_/B VGND VGND VPWR VPWR _2869_/A sky130_fd_sc_hd__nand2_1
X_4606_ _4752_/CLK _4606_/D fanout136/X VGND VGND VPWR VPWR _4606_/Q sky130_fd_sc_hd__dfrtp_1
X_2798_ _2798_/A _2798_/B VGND VGND VPWR VPWR _2799_/B sky130_fd_sc_hd__xnor2_4
XFILLER_89_103 VGND VGND VPWR VPWR sky130_fd_sc_hd__decap_8
X_4537_ _4539_/CLK _4537_/D fanout169/X VGND VGND VPWR VPWR _4537_/Q sky130_fd_sc_hd__dfrtp_4
X_4468_ _4708_/CLK _4468_/D fanout164/X VGND VGND VPWR VPWR _4468_/Q sky130_fd_sc_hd__dfrtp_1
XFILLER_104_469 VGND VGND VPWR VPWR sky130_fd_sc_hd__decap_6
XFILLER_89_169 VGND VGND VPWR VPWR sky130_fd_sc_hd__fill_1
X_3419_ _3495_/A _3419_/B VGND VGND VPWR VPWR _3420_/B sky130_fd_sc_hd__or2_1
X_4399_ _4542_/CLK _4399_/D fanout167/X VGND VGND VPWR VPWR _4399_/Q sky130_fd_sc_hd__dfrtp_1
XFILLER_58_501 VPWR VGND VPWR VGND sky130_ef_sc_hd__decap_12
XFILLER_58_545 VPWR VGND VPWR VGND sky130_ef_sc_hd__decap_12
XFILLER_93_39 VPWR VGND VPWR VGND sky130_ef_sc_hd__decap_12
XFILLER_58_589 VPWR VGND VPWR VGND sky130_ef_sc_hd__decap_12
XFILLER_73_559 VGND VGND VPWR VPWR sky130_fd_sc_hd__fill_1
XFILLER_26_77 VGND VGND VPWR VPWR sky130_fd_sc_hd__decap_6
XFILLER_26_486 VGND VGND VPWR VPWR sky130_fd_sc_hd__decap_4
XFILLER_13_169 VGND VGND VPWR VPWR sky130_fd_sc_hd__decap_4
XFILLER_42_65 VPWR VGND VPWR VGND sky130_ef_sc_hd__decap_12
XTAP_TAPCELL_ROW_11_348 VGND VPWR sky130_fd_sc_hd__tapvpwrvgnd_1
XFILLER_68_309 VGND VGND VPWR VPWR sky130_fd_sc_hd__decap_4
XFILLER_3_15 VPWR VGND VPWR VGND sky130_ef_sc_hd__decap_12
XFILLER_67_51 VGND VGND VPWR VPWR sky130_fd_sc_hd__decap_4
XFILLER_1_585 VPWR VGND VPWR VGND sky130_ef_sc_hd__decap_12
XFILLER_49_578 VPWR VGND VPWR VGND sky130_ef_sc_hd__decap_12
XTAP_TAPCELL_ROW_19_437 VGND VPWR sky130_fd_sc_hd__tapvpwrvgnd_1
XTAP_TAPCELL_ROW_47_746 VGND VPWR sky130_fd_sc_hd__tapvpwrvgnd_1
XFILLER_17_453 VGND VGND VPWR VPWR sky130_fd_sc_hd__fill_1
XFILLER_72_581 VGND VGND VPWR VPWR sky130_fd_sc_hd__decap_6
XTAP_TAPCELL_ROW_106_1398 VGND VPWR sky130_fd_sc_hd__tapvpwrvgnd_1
XFILLER_32_445 VGND VGND VPWR VPWR sky130_fd_sc_hd__decap_8
X_3770_ _3978_/A _3768_/Y _3769_/X _3979_/B2 _4543_/Q VGND VGND VPWR VPWR _4543_/D
+ sky130_fd_sc_hd__a32o_1
XFILLER_20_629 VGND VGND VPWR VPWR sky130_fd_sc_hd__decap_8
X_2721_ _2721_/A _2721_/B VGND VGND VPWR VPWR _2730_/A sky130_fd_sc_hd__or2_1
XFILLER_66_3 VPWR VGND VPWR VGND sky130_ef_sc_hd__decap_12
XFILLER_8_195 VGND VGND VPWR VPWR sky130_fd_sc_hd__fill_1
XFILLER_8_184 VGND VGND VPWR VPWR sky130_fd_sc_hd__fill_1
X_2652_ _4741_/Q _2652_/B VGND VGND VPWR VPWR _2653_/B sky130_fd_sc_hd__nor2_1
X_2583_ _4523_/Q _4528_/Q VGND VGND VPWR VPWR _2584_/B sky130_fd_sc_hd__xor2_1
XTAP_TAPCELL_ROW_74_1044 VGND VPWR sky130_fd_sc_hd__tapvpwrvgnd_1
X_4322_ _4489_/Q _4322_/B VGND VGND VPWR VPWR _4322_/Y sky130_fd_sc_hd__xnor2_1
Xfanout108 _4527_/Q VGND VGND VPWR VPWR _3382_/A sky130_fd_sc_hd__buf_2
X_4253_ _4713_/Q _4253_/B VGND VGND VPWR VPWR _4253_/X sky130_fd_sc_hd__or2_1
Xfanout119 _4360_/Q VGND VGND VPWR VPWR _4113_/A sky130_fd_sc_hd__clkbuf_1
XFILLER_101_417 VPWR VGND VPWR VGND sky130_ef_sc_hd__decap_12
XFILLER_87_629 VGND VGND VPWR VPWR sky130_fd_sc_hd__decap_8
X_3204_ _3204_/A _3204_/B VGND VGND VPWR VPWR _3207_/B sky130_fd_sc_hd__xnor2_1
X_4184_ _4187_/B VGND VGND VPWR VPWR _4184_/Y sky130_fd_sc_hd__inv_2
X_3135_ _3113_/B _3115_/B _3111_/X VGND VGND VPWR VPWR _3137_/B sky130_fd_sc_hd__a21o_1
XFILLER_103_27 VPWR VGND VPWR VGND sky130_ef_sc_hd__decap_12
XFILLER_67_386 VGND VGND VPWR VPWR sky130_fd_sc_hd__decap_6
X_3066_ _3791_/A _3067_/B VGND VGND VPWR VPWR _3066_/X sky130_fd_sc_hd__and2_1
XFILLER_27_239 VGND VGND VPWR VPWR sky130_fd_sc_hd__fill_1
XFILLER_55_559 VGND VGND VPWR VPWR sky130_fd_sc_hd__fill_1
XTAP_TAPCELL_ROW_85_1162 VGND VPWR sky130_fd_sc_hd__tapvpwrvgnd_1
XFILLER_50_220 VGND VGND VPWR VPWR sky130_fd_sc_hd__decap_8
X_3968_ _3968_/A _3968_/B VGND VGND VPWR VPWR _3970_/A sky130_fd_sc_hd__nor2_1
XFILLER_10_139 VGND VGND VPWR VPWR sky130_fd_sc_hd__fill_1
X_2919_ _2919_/A _2919_/B _2919_/C VGND VGND VPWR VPWR _2920_/B sky130_fd_sc_hd__nor3_1
X_3899_ _3898_/A _3898_/B _3900_/A VGND VGND VPWR VPWR _3918_/B sky130_fd_sc_hd__a21bo_1
XFILLER_2_305 VGND VGND VPWR VPWR sky130_fd_sc_hd__decap_3
XTAP_TAPCELL_ROW_96_1291 VGND VPWR sky130_fd_sc_hd__tapvpwrvgnd_1
Xhold140 _4644_/Q VGND VGND VPWR VPWR hold140/X sky130_fd_sc_hd__dlygate4sd3_1
Xhold151 _4656_/Q VGND VGND VPWR VPWR hold151/X sky130_fd_sc_hd__dlygate4sd3_1
Xhold162 _4574_/Q VGND VGND VPWR VPWR hold162/X sky130_fd_sc_hd__dlygate4sd3_1
XFILLER_104_233 VPWR VGND VPWR VGND sky130_ef_sc_hd__decap_12
Xhold195 _4587_/Q VGND VGND VPWR VPWR hold195/X sky130_fd_sc_hd__dlygate4sd3_1
Xhold184 _4579_/Q VGND VGND VPWR VPWR hold184/X sky130_fd_sc_hd__dlygate4sd3_1
Xhold173 _4484_/Q VGND VGND VPWR VPWR hold173/X sky130_fd_sc_hd__dlygate4sd3_1
XFILLER_104_277 VPWR VGND VPWR VGND sky130_ef_sc_hd__decap_12
XFILLER_46_526 VGND VGND VPWR VPWR sky130_fd_sc_hd__decap_6
XFILLER_46_537 VGND VGND VPWR VPWR sky130_fd_sc_hd__fill_1
XFILLER_61_529 VPWR VGND VPWR VGND sky130_ef_sc_hd__decap_12
XTAP_TAPCELL_ROW_16_407 VGND VPWR sky130_fd_sc_hd__tapvpwrvgnd_1
XTAP_TAPCELL_ROW_44_716 VGND VPWR sky130_fd_sc_hd__tapvpwrvgnd_1
XFILLER_54_581 VGND VGND VPWR VPWR sky130_fd_sc_hd__decap_6
XFILLER_26_283 VPWR VGND VPWR VGND sky130_ef_sc_hd__decap_12
XTAP_TAPCELL_ROW_24_495 VGND VPWR sky130_fd_sc_hd__tapvpwrvgnd_1
XFILLER_78_83 VGND VGND VPWR VPWR sky130_fd_sc_hd__fill_1
XFILLER_69_629 VGND VGND VPWR VPWR sky130_fd_sc_hd__decap_8
XFILLER_76_161 VGND VGND VPWR VPWR sky130_fd_sc_hd__fill_1
XFILLER_64_323 VGND VGND VPWR VPWR sky130_fd_sc_hd__fill_2
XFILLER_64_356 VGND VGND VPWR VPWR sky130_fd_sc_hd__decap_8
XFILLER_64_345 VGND VGND VPWR VPWR sky130_fd_sc_hd__decap_4
XFILLER_24_209 VGND VGND VPWR VPWR sky130_fd_sc_hd__decap_3
XFILLER_64_378 VGND VGND VPWR VPWR sky130_fd_sc_hd__decap_8
X_3822_ _3822_/A _3822_/B _3822_/C _3822_/D VGND VGND VPWR VPWR _3823_/B sky130_fd_sc_hd__nand4_1
XFILLER_20_426 VGND VGND VPWR VPWR sky130_fd_sc_hd__decap_8
X_3753_ _3858_/A _3753_/B VGND VGND VPWR VPWR _3754_/B sky130_fd_sc_hd__and2_1
X_3684_ _3684_/A _3684_/B VGND VGND VPWR VPWR _3718_/B sky130_fd_sc_hd__xnor2_2
X_2704_ _4497_/Q _2705_/B VGND VGND VPWR VPWR _2704_/X sky130_fd_sc_hd__and2_1
X_2635_ _4526_/Q _2636_/B VGND VGND VPWR VPWR _2637_/A sky130_fd_sc_hd__nand2_1
X_2566_ hold192/X _4735_/Q _2566_/S VGND VGND VPWR VPWR _4489_/D sky130_fd_sc_hd__mux2_1
X_4305_ _4409_/Q hold23/A _4425_/Q _4433_/Q _4319_/S0 _2427_/B VGND VGND VPWR VPWR
+ _4306_/A sky130_fd_sc_hd__mux4_1
X_2497_ _2526_/A1 _2494_/Y _2498_/B _2526_/B1 hold75/X VGND VGND VPWR VPWR _4460_/D
+ sky130_fd_sc_hd__a32o_1
XFILLER_101_225 VPWR VGND VPWR VGND sky130_ef_sc_hd__decap_12
X_4236_ _4239_/B VGND VGND VPWR VPWR _4240_/B sky130_fd_sc_hd__inv_2
XFILLER_67_150 VGND VGND VPWR VPWR sky130_fd_sc_hd__decap_6
X_4167_ _4688_/Q _4169_/C VGND VGND VPWR VPWR _4167_/X sky130_fd_sc_hd__or2_1
XFILLER_28_515 VGND VGND VPWR VPWR sky130_fd_sc_hd__decap_8
X_3118_ _3836_/A _3119_/B VGND VGND VPWR VPWR _3118_/Y sky130_fd_sc_hd__nand2_1
X_4098_ _4013_/B _4016_/B _4134_/A1 _4094_/Y hold71/X VGND VGND VPWR VPWR _4631_/D
+ sky130_fd_sc_hd__a32o_1
XFILLER_82_175 VGND VGND VPWR VPWR sky130_fd_sc_hd__decap_8
XFILLER_70_304 VGND VGND VPWR VPWR sky130_fd_sc_hd__decap_4
X_3049_ _3049_/A _3049_/B VGND VGND VPWR VPWR _3050_/B sky130_fd_sc_hd__xnor2_2
XFILLER_43_518 VGND VGND VPWR VPWR sky130_fd_sc_hd__decap_4
XFILLER_90_29 VPWR VGND VPWR VGND sky130_ef_sc_hd__decap_12
XFILLER_11_437 VGND VGND VPWR VPWR sky130_fd_sc_hd__decap_8
XFILLER_23_286 VPWR VGND VPWR VGND sky130_ef_sc_hd__decap_12
XFILLER_99_27 VPWR VGND VPWR VGND sky130_ef_sc_hd__decap_12
XTAP_TAPCELL_ROW_21_465 VGND VPWR sky130_fd_sc_hd__tapvpwrvgnd_1
XFILLER_23_89 VGND VGND VPWR VPWR sky130_fd_sc_hd__decap_3
XFILLER_3_603 VGND VGND VPWR VPWR sky130_fd_sc_hd__fill_1
XFILLER_105_553 VGND VGND VPWR VPWR sky130_fd_sc_hd__decap_6
XFILLER_105_597 VPWR VGND VPWR VGND sky130_ef_sc_hd__decap_12
XFILLER_93_429 VPWR VGND VPWR VGND sky130_ef_sc_hd__decap_12
XFILLER_48_53 VPWR VGND VPWR VGND sky130_ef_sc_hd__decap_12
XFILLER_0_49 VGND VGND VPWR VPWR sky130_fd_sc_hd__fill_2
XTAP_TAPCELL_ROW_29_554 VGND VPWR sky130_fd_sc_hd__tapvpwrvgnd_1
XTAP_TAPCELL_ROW_57_863 VGND VPWR sky130_fd_sc_hd__tapvpwrvgnd_1
XFILLER_64_41 VPWR VGND VPWR VGND sky130_ef_sc_hd__decap_12
XFILLER_46_389 VPWR VGND VPWR VGND sky130_ef_sc_hd__decap_12
XTAP_TAPCELL_ROW_103_1368 VGND VPWR sky130_fd_sc_hd__tapvpwrvgnd_1
XFILLER_14_253 VGND VGND VPWR VPWR sky130_fd_sc_hd__decap_8
XFILLER_42_562 VGND VGND VPWR VPWR sky130_fd_sc_hd__fill_1
XFILLER_9_69 VPWR VGND VPWR VGND sky130_ef_sc_hd__decap_12
Xfanout90 _2431_/Y VGND VGND VPWR VPWR _3081_/A2 sky130_fd_sc_hd__buf_2
XFILLER_80_95 VPWR VGND VPWR VGND sky130_ef_sc_hd__decap_12
XFILLER_6_441 VPWR VGND VPWR VGND sky130_ef_sc_hd__decap_12
X_2420_ hold235/X _2420_/A2 _2420_/B1 _4521_/Q VGND VGND VPWR VPWR _2420_/X sky130_fd_sc_hd__a22o_1
X_2351_ _4149_/B _4363_/Q VGND VGND VPWR VPWR _2352_/B sky130_fd_sc_hd__nand2b_1
XTAP_TAPCELL_ROW_71_1014 VGND VPWR sky130_fd_sc_hd__tapvpwrvgnd_1
XFILLER_69_426 VGND VGND VPWR VPWR sky130_fd_sc_hd__decap_6
XFILLER_96_245 VGND VGND VPWR VPWR sky130_fd_sc_hd__decap_6
X_2282_ _4704_/Q _2495_/A VGND VGND VPWR VPWR _2282_/X sky130_fd_sc_hd__or2_1
XFILLER_84_418 VGND VGND VPWR VPWR sky130_fd_sc_hd__fill_2
XFILLER_29_3 VPWR VGND VPWR VGND sky130_ef_sc_hd__decap_12
X_4021_ _4095_/B _4016_/B _4134_/A1 _4016_/Y hold68/X VGND VGND VPWR VPWR _4567_/D
+ sky130_fd_sc_hd__a32o_1
XFILLER_49_150 VGND VGND VPWR VPWR sky130_fd_sc_hd__decap_8
XFILLER_96_289 VPWR VGND VPWR VGND sky130_ef_sc_hd__decap_12
XFILLER_80_613 VPWR VGND VPWR VGND sky130_ef_sc_hd__decap_12
XTAP_TAPCELL_ROW_82_1132 VGND VPWR sky130_fd_sc_hd__tapvpwrvgnd_1
XFILLER_64_197 VGND VGND VPWR VPWR sky130_fd_sc_hd__decap_8
X_3805_ _3805_/A _3805_/B VGND VGND VPWR VPWR _3822_/A sky130_fd_sc_hd__nand2_1
X_4785_ _4785_/A VGND VGND VPWR VPWR uio_out[1] sky130_fd_sc_hd__buf_2
X_3736_ _3649_/X _3681_/X _3732_/X _3735_/Y _3699_/A VGND VGND VPWR VPWR _3740_/B
+ sky130_fd_sc_hd__o311a_1
X_3667_ _4754_/Q _3667_/B VGND VGND VPWR VPWR _3668_/B sky130_fd_sc_hd__nand2_1
XTAP_TAPCELL_ROW_93_1250 VGND VPWR sky130_fd_sc_hd__tapvpwrvgnd_1
X_2618_ _2618_/A _2618_/B VGND VGND VPWR VPWR _2620_/B sky130_fd_sc_hd__xnor2_1
X_3598_ _3652_/C _3598_/B VGND VGND VPWR VPWR _3601_/A sky130_fd_sc_hd__nor2_1
XFILLER_102_501 VPWR VGND VPWR VGND sky130_ef_sc_hd__decap_12
XFILLER_0_617 VPWR VGND VPWR VGND sky130_ef_sc_hd__decap_12
X_2549_ _2432_/A _2547_/Y _2548_/X _3813_/A2 hold243/X VGND VGND VPWR VPWR _4477_/D
+ sky130_fd_sc_hd__a32o_1
XFILLER_102_545 VPWR VGND VPWR VGND sky130_ef_sc_hd__decap_12
XFILLER_102_589 VPWR VGND VPWR VGND sky130_ef_sc_hd__decap_12
XFILLER_87_256 VGND VGND VPWR VPWR sky130_fd_sc_hd__fill_2
X_4219_ _4703_/Q _4218_/B _4238_/A1 VGND VGND VPWR VPWR _4219_/Y sky130_fd_sc_hd__o21ai_1
XFILLER_28_345 VGND VGND VPWR VPWR sky130_fd_sc_hd__decap_8
XFILLER_55_142 VPWR VGND VPWR VGND sky130_ef_sc_hd__decap_12
XFILLER_83_473 VPWR VGND VPWR VGND sky130_ef_sc_hd__decap_12
XTAP_TAPCELL_ROW_26_513 VGND VPWR sky130_fd_sc_hd__tapvpwrvgnd_1
XTAP_TAPCELL_ROW_54_822 VGND VPWR sky130_fd_sc_hd__tapvpwrvgnd_1
XFILLER_55_175 VGND VGND VPWR VPWR sky130_fd_sc_hd__decap_8
XFILLER_70_134 VGND VGND VPWR VPWR sky130_fd_sc_hd__decap_6
XFILLER_43_337 VGND VGND VPWR VPWR sky130_fd_sc_hd__decap_6
XFILLER_51_370 VGND VGND VPWR VPWR sky130_fd_sc_hd__decap_4
XFILLER_50_65 VPWR VGND VPWR VGND sky130_ef_sc_hd__decap_12
XFILLER_105_361 VPWR VGND VPWR VGND sky130_ef_sc_hd__decap_12
XFILLER_93_204 VPWR VGND VPWR VGND sky130_ef_sc_hd__decap_12
XFILLER_59_481 VPWR VGND VPWR VGND sky130_ef_sc_hd__decap_12
XTAP_TAPCELL_ROW_6_293 VGND VPWR sky130_fd_sc_hd__tapvpwrvgnd_1
XFILLER_75_51 VGND VGND VPWR VPWR sky130_fd_sc_hd__decap_4
XFILLER_62_613 VPWR VGND VPWR VGND sky130_ef_sc_hd__decap_12
XFILLER_19_389 VGND VGND VPWR VPWR sky130_fd_sc_hd__decap_3
XFILLER_46_197 VGND VGND VPWR VPWR sky130_fd_sc_hd__decap_4
XFILLER_61_167 VGND VGND VPWR VPWR sky130_fd_sc_hd__fill_1
XFILLER_15_584 VPWR VGND VPWR VGND sky130_ef_sc_hd__decap_12
X_4570_ _4667_/CLK _4570_/D fanout125/X VGND VGND VPWR VPWR hold78/A sky130_fd_sc_hd__dfrtp_1
X_3521_ _3521_/A _3522_/B VGND VGND VPWR VPWR _3521_/X sky130_fd_sc_hd__or2_1
X_3452_ _3541_/A _3453_/B VGND VGND VPWR VPWR _3525_/B sky130_fd_sc_hd__or2_1
X_3383_ _3382_/B _3382_/C _3382_/A VGND VGND VPWR VPWR _3383_/Y sky130_fd_sc_hd__o21ai_1
X_2403_ hold15/X _2407_/A2 _2407_/B1 _4504_/Q VGND VGND VPWR VPWR hold16/A sky130_fd_sc_hd__a22o_1
X_2334_ input7/X _4718_/D VGND VGND VPWR VPWR _4733_/D sky130_fd_sc_hd__and2_1
XFILLER_29_109 VGND VGND VPWR VPWR sky130_fd_sc_hd__decap_3
X_2265_ _2265_/A VGND VGND VPWR VPWR _2319_/A sky130_fd_sc_hd__inv_2
XFILLER_84_259 VGND VGND VPWR VPWR sky130_fd_sc_hd__fill_1
X_4004_ hold87/X _4732_/Q _4007_/S VGND VGND VPWR VPWR _4561_/D sky130_fd_sc_hd__mux2_1
X_2196_ hold85/A VGND VGND VPWR VPWR _2459_/A sky130_fd_sc_hd__inv_2
XFILLER_65_473 VPWR VGND VPWR VGND sky130_ef_sc_hd__decap_12
XFILLER_1_81 VPWR VGND VPWR VGND sky130_ef_sc_hd__decap_12
XFILLER_40_307 VGND VGND VPWR VPWR sky130_fd_sc_hd__fill_1
XFILLER_33_370 VGND VGND VPWR VPWR sky130_fd_sc_hd__fill_2
XFILLER_40_329 VGND VGND VPWR VPWR sky130_fd_sc_hd__fill_1
XTAP_TAPCELL_ROW_31_571 VGND VPWR sky130_fd_sc_hd__tapvpwrvgnd_1
X_4768_ _4770_/CLK _4768_/D fanout162/X VGND VGND VPWR VPWR _4768_/Q sky130_fd_sc_hd__dfstp_1
X_3719_ _3687_/A _3693_/B _3718_/C _3718_/X _3712_/A VGND VGND VPWR VPWR _3839_/A
+ sky130_fd_sc_hd__o311a_1
X_4699_ _4699_/CLK _4699_/D fanout159/X VGND VGND VPWR VPWR _4699_/Q sky130_fd_sc_hd__dfrtp_1
Xhold11 hold11/A VGND VGND VPWR VPWR hold11/X sky130_fd_sc_hd__dlygate4sd3_1
Xhold22 hold22/A VGND VGND VPWR VPWR hold22/X sky130_fd_sc_hd__dlygate4sd3_1
XFILLER_88_587 VGND VGND VPWR VPWR sky130_fd_sc_hd__fill_1
Xhold44 hold44/A VGND VGND VPWR VPWR hold44/X sky130_fd_sc_hd__dlygate4sd3_1
XFILLER_29_55 VGND VGND VPWR VPWR sky130_fd_sc_hd__fill_1
XFILLER_29_77 VGND VGND VPWR VPWR sky130_fd_sc_hd__fill_2
Xhold33 hold33/A VGND VGND VPWR VPWR hold33/X sky130_fd_sc_hd__dlygate4sd3_1
Xhold55 hold55/A VGND VGND VPWR VPWR hold55/X sky130_fd_sc_hd__dlygate4sd3_1
Xhold88 hold88/A VGND VGND VPWR VPWR hold88/X sky130_fd_sc_hd__dlygate4sd3_1
Xhold66 hold66/A VGND VGND VPWR VPWR hold66/X sky130_fd_sc_hd__dlygate4sd3_1
Xhold99 hold99/A VGND VGND VPWR VPWR hold99/X sky130_fd_sc_hd__dlygate4sd3_1
Xhold77 hold77/A VGND VGND VPWR VPWR hold77/X sky130_fd_sc_hd__dlygate4sd3_1
XTAP_TAPCELL_ROW_3_263 VGND VPWR sky130_fd_sc_hd__tapvpwrvgnd_1
XTAP_TAPCELL_ROW_39_660 VGND VPWR sky130_fd_sc_hd__tapvpwrvgnd_1
XFILLER_83_281 VPWR VGND VPWR VGND sky130_ef_sc_hd__decap_12
XFILLER_45_65 VGND VGND VPWR VPWR sky130_fd_sc_hd__decap_3
XFILLER_43_167 VGND VGND VPWR VPWR sky130_fd_sc_hd__fill_1
XFILLER_43_189 VPWR VGND VPWR VGND sky130_ef_sc_hd__decap_12
XFILLER_101_93 VPWR VGND VPWR VGND sky130_ef_sc_hd__decap_12
XTAP_TAPCELL_ROW_100_1327 VGND VPWR sky130_fd_sc_hd__tapvpwrvgnd_1
XFILLER_6_15 VPWR VGND VPWR VGND sky130_ef_sc_hd__decap_12
XFILLER_98_307 VGND VGND VPWR VPWR sky130_fd_sc_hd__fill_1
XFILLER_94_513 VPWR VGND VPWR VGND sky130_ef_sc_hd__decap_12
XFILLER_86_83 VGND VGND VPWR VPWR sky130_fd_sc_hd__fill_1
XFILLER_94_557 VPWR VGND VPWR VGND sky130_ef_sc_hd__decap_12
XFILLER_81_207 VPWR VGND VPWR VGND sky130_ef_sc_hd__decap_12
XFILLER_19_186 VGND VGND VPWR VPWR sky130_fd_sc_hd__fill_1
XFILLER_62_465 VGND VGND VPWR VPWR sky130_fd_sc_hd__decap_8
XFILLER_96_3 VPWR VGND VPWR VGND sky130_ef_sc_hd__decap_12
X_2952_ _4507_/Q _2952_/B VGND VGND VPWR VPWR _2953_/B sky130_fd_sc_hd__nor2_1
X_2883_ hold47/A _4604_/Q hold62/A hold93/A _2746_/S _3174_/S1 VGND VGND VPWR VPWR
+ _2885_/B sky130_fd_sc_hd__mux4_1
X_4622_ _4737_/CLK _4622_/D fanout122/X VGND VGND VPWR VPWR _4622_/Q sky130_fd_sc_hd__dfrtp_1
X_4553_ clkload3/A _4553_/D fanout145/X VGND VGND VPWR VPWR hold4/A sky130_fd_sc_hd__dfrtp_4
X_4484_ _4735_/CLK _4484_/D fanout149/X VGND VGND VPWR VPWR _4484_/Q sky130_fd_sc_hd__dfrtp_1
X_3504_ _3519_/S _3504_/B VGND VGND VPWR VPWR _3516_/B sky130_fd_sc_hd__nand2_1
XTAP_TAPCELL_ROW_77_1075 VGND VPWR sky130_fd_sc_hd__tapvpwrvgnd_1
X_3435_ _3436_/B VGND VGND VPWR VPWR _3435_/Y sky130_fd_sc_hd__inv_2
XFILLER_106_27 VGND VGND VPWR VPWR sky130_fd_sc_hd__fill_1
XTAP_TAPCELL_ROW_90_1220 VGND VPWR sky130_fd_sc_hd__tapvpwrvgnd_1
X_3366_ _3366_/A _3366_/B _3366_/C VGND VGND VPWR VPWR _3368_/C sky130_fd_sc_hd__nand3_1
XFILLER_97_373 VPWR VGND VPWR VGND sky130_ef_sc_hd__decap_12
X_3297_ _3298_/A _3298_/B VGND VGND VPWR VPWR _3297_/X sky130_fd_sc_hd__or2_1
X_2317_ _2313_/X _2316_/X _2288_/X VGND VGND VPWR VPWR _2320_/B sky130_fd_sc_hd__a21oi_1
XFILLER_57_215 VGND VGND VPWR VPWR sky130_fd_sc_hd__decap_4
X_2248_ _2427_/A _2249_/B VGND VGND VPWR VPWR _2248_/Y sky130_fd_sc_hd__nand2_1
XTAP_TAPCELL_ROW_0_222 VGND VPWR sky130_fd_sc_hd__tapvpwrvgnd_1
XTAP_TAPCELL_ROW_0_233 VGND VPWR sky130_fd_sc_hd__tapvpwrvgnd_1
X_2179_ _2427_/A VGND VGND VPWR VPWR _2422_/A sky130_fd_sc_hd__inv_2
XFILLER_13_307 VGND VGND VPWR VPWR sky130_fd_sc_hd__decap_3
XTAP_TAPCELL_ROW_36_630 VGND VPWR sky130_fd_sc_hd__tapvpwrvgnd_1
XFILLER_53_443 VGND VGND VPWR VPWR sky130_fd_sc_hd__decap_4
XFILLER_15_57 VPWR VGND VPWR VGND sky130_ef_sc_hd__decap_12
XFILLER_21_362 VGND VGND VPWR VPWR sky130_fd_sc_hd__fill_2
XFILLER_21_384 VGND VGND VPWR VPWR sky130_fd_sc_hd__decap_8
XFILLER_107_445 VGND VGND VPWR VPWR sky130_fd_sc_hd__decap_3
XFILLER_5_539 VGND VGND VPWR VPWR sky130_fd_sc_hd__fill_1
XFILLER_107_489 VPWR VGND VPWR VGND sky130_ef_sc_hd__decap_12
XTAP_TAPCELL_ROW_8_322 VGND VPWR sky130_fd_sc_hd__tapvpwrvgnd_1
XFILLER_76_513 VPWR VGND VPWR VGND sky130_ef_sc_hd__decap_12
XFILLER_0_277 VGND VGND VPWR VPWR sky130_fd_sc_hd__decap_3
XFILLER_76_557 VPWR VGND VPWR VGND sky130_ef_sc_hd__decap_12
XFILLER_91_505 VPWR VGND VPWR VGND sky130_ef_sc_hd__decap_12
XFILLER_56_53 VPWR VGND VPWR VGND sky130_ef_sc_hd__decap_12
XFILLER_44_410 VGND VGND VPWR VPWR sky130_fd_sc_hd__decap_8
XFILLER_44_421 VGND VGND VPWR VPWR sky130_fd_sc_hd__fill_2
XTAP_TAPCELL_ROW_62_909 VGND VPWR sky130_fd_sc_hd__tapvpwrvgnd_1
XFILLER_72_41 VPWR VGND VPWR VGND sky130_ef_sc_hd__decap_12
XFILLER_72_85 VGND VGND VPWR VPWR sky130_fd_sc_hd__decap_3
XFILLER_72_96 VGND VGND VPWR VPWR sky130_fd_sc_hd__fill_2
XTAP_TAPCELL_ROW_70_997 VGND VPWR sky130_fd_sc_hd__tapvpwrvgnd_1
XTAP_TAPCELL_ROW_42_699 VGND VPWR sky130_fd_sc_hd__tapvpwrvgnd_1
X_3220_ _3220_/A _3220_/B VGND VGND VPWR VPWR _3221_/B sky130_fd_sc_hd__nand2_1
XFILLER_100_109 VPWR VGND VPWR VGND sky130_ef_sc_hd__decap_12
XFILLER_97_93 VPWR VGND VPWR VGND sky130_ef_sc_hd__decap_12
XFILLER_79_384 VGND VGND VPWR VPWR sky130_fd_sc_hd__fill_1
X_3151_ _3151_/A _3151_/B VGND VGND VPWR VPWR _3860_/A sky130_fd_sc_hd__xnor2_4
XFILLER_11_3 VPWR VGND VPWR VGND sky130_ef_sc_hd__decap_12
XFILLER_39_259 VGND VGND VPWR VPWR sky130_fd_sc_hd__decap_3
XFILLER_94_365 VPWR VGND VPWR VGND sky130_ef_sc_hd__decap_12
X_3082_ _4580_/Q _4612_/Q _4644_/Q _4676_/Q _3246_/S0 _3246_/S1 VGND VGND VPWR VPWR
+ _3084_/B sky130_fd_sc_hd__mux4_1
XFILLER_62_251 VGND VGND VPWR VPWR sky130_fd_sc_hd__fill_1
XTAP_TAPCELL_ROW_33_600 VGND VPWR sky130_fd_sc_hd__tapvpwrvgnd_1
XFILLER_35_487 VGND VGND VPWR VPWR sky130_fd_sc_hd__decap_4
X_3984_ _4767_/Q _3984_/B VGND VGND VPWR VPWR _3985_/B sky130_fd_sc_hd__xnor2_1
XFILLER_50_435 VPWR VGND VPWR VGND sky130_ef_sc_hd__decap_12
X_2935_ hold295/X _4345_/A2 _3737_/A _4345_/B2 VGND VGND VPWR VPWR _4506_/D sky130_fd_sc_hd__a22o_1
XTAP_TAPCELL_ROW_79_1104 VGND VPWR sky130_fd_sc_hd__tapvpwrvgnd_1
X_2866_ _4532_/Q _4541_/Q VGND VGND VPWR VPWR _2868_/B sky130_fd_sc_hd__xor2_1
XFILLER_30_192 VGND VGND VPWR VPWR sky130_fd_sc_hd__fill_1
X_4605_ _4752_/CLK _4605_/D fanout133/X VGND VGND VPWR VPWR _4605_/Q sky130_fd_sc_hd__dfrtp_1
Xhold300 _4492_/Q VGND VGND VPWR VPWR hold300/X sky130_fd_sc_hd__dlygate4sd3_1
X_2797_ _2797_/A _2819_/B VGND VGND VPWR VPWR _2798_/B sky130_fd_sc_hd__xnor2_2
X_4536_ _4536_/CLK _4536_/D fanout169/X VGND VGND VPWR VPWR _4536_/Q sky130_fd_sc_hd__dfrtp_4
X_4467_ _4708_/CLK _4467_/D fanout164/X VGND VGND VPWR VPWR _4467_/Q sky130_fd_sc_hd__dfrtp_1
X_4398_ _4538_/CLK hold29/X fanout167/X VGND VGND VPWR VPWR _4398_/Q sky130_fd_sc_hd__dfrtp_1
X_3418_ _3495_/A _3419_/B VGND VGND VPWR VPWR _3418_/X sky130_fd_sc_hd__and2_1
X_3349_ _3348_/B _3348_/C _3272_/A VGND VGND VPWR VPWR _3351_/C sky130_fd_sc_hd__a21bo_1
XFILLER_58_513 VPWR VGND VPWR VGND sky130_ef_sc_hd__decap_12
XFILLER_97_181 VPWR VGND VPWR VGND sky130_ef_sc_hd__decap_12
XFILLER_58_557 VPWR VGND VPWR VGND sky130_ef_sc_hd__decap_12
XFILLER_73_505 VPWR VGND VPWR VGND sky130_ef_sc_hd__decap_12
XFILLER_26_421 VPWR VGND VPWR VGND sky130_ef_sc_hd__decap_12
XFILLER_38_281 VGND VGND VPWR VPWR sky130_fd_sc_hd__decap_4
XFILLER_38_292 VGND VGND VPWR VPWR sky130_fd_sc_hd__decap_4
XFILLER_42_77 VGND VGND VPWR VPWR sky130_fd_sc_hd__decap_6
XTAP_TAPCELL_ROW_11_349 VGND VPWR sky130_fd_sc_hd__tapvpwrvgnd_1
XFILLER_5_314 VGND VGND VPWR VPWR sky130_fd_sc_hd__fill_2
XPHY_EDGE_ROW_2_Left_110 VGND VGND VPWR VPWR sky130_fd_sc_hd__decap_3
XFILLER_107_253 VPWR VGND VPWR VGND sky130_ef_sc_hd__decap_12
XPHY_EDGE_ROW_39_Left_147 VGND VGND VPWR VPWR sky130_fd_sc_hd__decap_3
XFILLER_3_27 VPWR VGND VPWR VGND sky130_ef_sc_hd__decap_12
XFILLER_107_81 VGND VGND VPWR VPWR sky130_fd_sc_hd__decap_3
XFILLER_49_524 VPWR VGND VPWR VGND sky130_ef_sc_hd__decap_12
XFILLER_1_597 VPWR VGND VPWR VGND sky130_ef_sc_hd__decap_12
XFILLER_91_335 VGND VGND VPWR VPWR sky130_fd_sc_hd__fill_1
XTAP_TAPCELL_ROW_19_438 VGND VPWR sky130_fd_sc_hd__tapvpwrvgnd_1
XFILLER_29_281 VPWR VGND VPWR VGND sky130_ef_sc_hd__decap_12
XTAP_TAPCELL_ROW_47_747 VGND VPWR sky130_fd_sc_hd__tapvpwrvgnd_1
XPHY_EDGE_ROW_48_Left_156 VGND VGND VPWR VPWR sky130_fd_sc_hd__decap_3
XFILLER_83_51 VGND VGND VPWR VPWR sky130_fd_sc_hd__decap_4
XFILLER_17_487 VPWR VGND VPWR VGND sky130_ef_sc_hd__decap_12
XFILLER_44_251 VGND VGND VPWR VPWR sky130_fd_sc_hd__fill_1
XTAP_TAPCELL_ROW_106_1399 VGND VPWR sky130_fd_sc_hd__tapvpwrvgnd_1
X_2720_ _2720_/A _2720_/B _2808_/A VGND VGND VPWR VPWR _2721_/B sky130_fd_sc_hd__and3_1
X_2651_ _4741_/Q _2652_/B VGND VGND VPWR VPWR _2673_/B sky130_fd_sc_hd__and2_1
XPHY_EDGE_ROW_57_Left_165 VGND VGND VPWR VPWR sky130_fd_sc_hd__decap_3
X_2582_ _4523_/Q _4528_/Q VGND VGND VPWR VPWR _2582_/X sky130_fd_sc_hd__and2_1
XFILLER_59_3 VPWR VGND VPWR VGND sky130_ef_sc_hd__decap_12
XTAP_TAPCELL_ROW_74_1045 VGND VPWR sky130_fd_sc_hd__tapvpwrvgnd_1
X_4321_ _4283_/A _4320_/Y _4318_/Y _2250_/A VGND VGND VPWR VPWR _4322_/B sky130_fd_sc_hd__a211o_1
Xfanout109 _4439_/Q VGND VGND VPWR VPWR _2250_/A sky130_fd_sc_hd__buf_2
X_4252_ _4253_/B _4251_/Y _4712_/Q _4262_/A VGND VGND VPWR VPWR _4712_/D sky130_fd_sc_hd__a2bb2o_1
XFILLER_101_429 VPWR VGND VPWR VGND sky130_ef_sc_hd__decap_12
X_3203_ _3203_/A _3203_/B VGND VGND VPWR VPWR _3204_/B sky130_fd_sc_hd__xnor2_1
X_4183_ _4692_/Q _4693_/Q _4183_/C VGND VGND VPWR VPWR _4187_/B sky130_fd_sc_hd__and3_1
X_3134_ _3159_/A _3134_/B VGND VGND VPWR VPWR _3137_/A sky130_fd_sc_hd__nand2_1
XPHY_EDGE_ROW_66_Left_174 VGND VGND VPWR VPWR sky130_fd_sc_hd__decap_3
XFILLER_103_39 VPWR VGND VPWR VGND sky130_ef_sc_hd__decap_12
XFILLER_94_195 VGND VGND VPWR VPWR sky130_fd_sc_hd__fill_1
XFILLER_82_313 VGND VGND VPWR VPWR sky130_fd_sc_hd__fill_1
X_3065_ _4540_/Q _4549_/Q VGND VGND VPWR VPWR _3067_/B sky130_fd_sc_hd__xor2_1
XFILLER_82_346 VGND VGND VPWR VPWR sky130_fd_sc_hd__decap_4
XTAP_TAPCELL_ROW_85_1163 VGND VPWR sky130_fd_sc_hd__tapvpwrvgnd_1
XFILLER_23_446 VGND VGND VPWR VPWR sky130_fd_sc_hd__fill_2
X_3967_ _3967_/A _3967_/B VGND VGND VPWR VPWR _3968_/B sky130_fd_sc_hd__nor2_1
X_2918_ _2871_/X _2919_/C _2917_/X VGND VGND VPWR VPWR _2920_/A sky130_fd_sc_hd__o21ai_1
X_3898_ _3898_/A _3898_/B VGND VGND VPWR VPWR _3900_/B sky130_fd_sc_hd__nand2_1
XPHY_EDGE_ROW_75_Left_183 VGND VGND VPWR VPWR sky130_fd_sc_hd__decap_3
Xclkbuf_leaf_30_clk clkload5/A VGND VGND VPWR VPWR _4536_/CLK sky130_fd_sc_hd__clkbuf_8
X_2849_ _2919_/B _2849_/B VGND VGND VPWR VPWR _2850_/B sky130_fd_sc_hd__xnor2_1
XTAP_TAPCELL_ROW_96_1292 VGND VPWR sky130_fd_sc_hd__tapvpwrvgnd_1
XFILLER_88_29 VPWR VGND VPWR VGND sky130_ef_sc_hd__decap_12
X_4519_ _4519_/CLK _4519_/D fanout170/X VGND VGND VPWR VPWR _4519_/Q sky130_fd_sc_hd__dfrtp_2
Xhold130 _4562_/Q VGND VGND VPWR VPWR hold130/X sky130_fd_sc_hd__dlygate4sd3_1
Xhold141 _4563_/Q VGND VGND VPWR VPWR hold141/X sky130_fd_sc_hd__dlygate4sd3_1
Xhold152 _4604_/Q VGND VGND VPWR VPWR hold152/X sky130_fd_sc_hd__dlygate4sd3_1
XFILLER_104_245 VGND VGND VPWR VPWR sky130_fd_sc_hd__decap_6
Xhold163 _4588_/Q VGND VGND VPWR VPWR hold163/X sky130_fd_sc_hd__dlygate4sd3_1
Xhold185 _4581_/Q VGND VGND VPWR VPWR hold185/X sky130_fd_sc_hd__dlygate4sd3_1
Xhold174 _4610_/Q VGND VGND VPWR VPWR hold174/X sky130_fd_sc_hd__dlygate4sd3_1
XFILLER_104_289 VPWR VGND VPWR VGND sky130_ef_sc_hd__decap_12
Xhold196 _4648_/Q VGND VGND VPWR VPWR hold196/X sky130_fd_sc_hd__dlygate4sd3_1
XPHY_EDGE_ROW_84_Left_192 VGND VGND VPWR VPWR sky130_fd_sc_hd__decap_3
XFILLER_73_324 VGND VGND VPWR VPWR sky130_fd_sc_hd__fill_2
XFILLER_37_55 VGND VGND VPWR VPWR sky130_fd_sc_hd__fill_1
XTAP_TAPCELL_ROW_16_408 VGND VPWR sky130_fd_sc_hd__tapvpwrvgnd_1
XFILLER_26_273 VGND VGND VPWR VPWR sky130_fd_sc_hd__decap_3
XTAP_TAPCELL_ROW_44_717 VGND VPWR sky130_fd_sc_hd__tapvpwrvgnd_1
XFILLER_26_295 VPWR VGND VPWR VGND sky130_ef_sc_hd__decap_12
XTAP_TAPCELL_ROW_24_496 VGND VPWR sky130_fd_sc_hd__tapvpwrvgnd_1
Xclkbuf_leaf_21_clk clkload3/A VGND VGND VPWR VPWR _4539_/CLK sky130_fd_sc_hd__clkbuf_8
XFILLER_5_177 VGND VGND VPWR VPWR sky130_fd_sc_hd__fill_1
XFILLER_68_129 VGND VGND VPWR VPWR sky130_fd_sc_hd__decap_3
XFILLER_91_110 VGND VGND VPWR VPWR sky130_fd_sc_hd__fill_2
XFILLER_94_83 VGND VGND VPWR VPWR sky130_fd_sc_hd__fill_1
XFILLER_76_195 VGND VGND VPWR VPWR sky130_fd_sc_hd__fill_1
X_3821_ _3822_/A _3822_/C _3822_/D _3822_/B VGND VGND VPWR VPWR _3856_/B sky130_fd_sc_hd__a31o_1
XFILLER_32_287 VGND VGND VPWR VPWR sky130_fd_sc_hd__fill_1
Xclkbuf_leaf_12_clk clkload2/A VGND VGND VPWR VPWR _4758_/CLK sky130_fd_sc_hd__clkbuf_8
X_3752_ _3858_/A _3753_/B VGND VGND VPWR VPWR _3785_/A sky130_fd_sc_hd__nor2_1
XFILLER_9_461 VGND VGND VPWR VPWR sky130_fd_sc_hd__fill_2
X_3683_ _3683_/A _3683_/B VGND VGND VPWR VPWR _3684_/B sky130_fd_sc_hd__xnor2_1
X_2703_ _2703_/A _2703_/B VGND VGND VPWR VPWR _2705_/B sky130_fd_sc_hd__xor2_1
X_2634_ _4531_/Q _4522_/Q VGND VGND VPWR VPWR _2636_/B sky130_fd_sc_hd__xor2_1
X_2565_ hold212/X _4734_/Q _2566_/S VGND VGND VPWR VPWR _4488_/D sky130_fd_sc_hd__mux2_1
X_4304_ _4318_/A _4304_/B VGND VGND VPWR VPWR _4304_/Y sky130_fd_sc_hd__nor2_1
X_2496_ _2501_/C VGND VGND VPWR VPWR _2498_/B sky130_fd_sc_hd__inv_2
XFILLER_101_237 VPWR VGND VPWR VGND sky130_ef_sc_hd__decap_12
XFILLER_87_449 VPWR VGND VPWR VGND sky130_ef_sc_hd__decap_12
X_4235_ _4708_/Q _4707_/Q _4235_/C VGND VGND VPWR VPWR _4239_/B sky130_fd_sc_hd__and3_1
X_4166_ _4688_/Q _4169_/C VGND VGND VPWR VPWR _4166_/Y sky130_fd_sc_hd__nand2_1
X_3117_ _3836_/A _3119_/B VGND VGND VPWR VPWR _3120_/A sky130_fd_sc_hd__and2_1
X_4097_ _4013_/B _4016_/B _4133_/A1 _4094_/Y hold43/X VGND VGND VPWR VPWR _4630_/D
+ sky130_fd_sc_hd__a32o_1
XFILLER_70_316 VGND VGND VPWR VPWR sky130_fd_sc_hd__decap_6
X_3048_ _3022_/A _3022_/B _3021_/A VGND VGND VPWR VPWR _3049_/B sky130_fd_sc_hd__a21oi_1
XFILLER_23_210 VPWR VGND VPWR VGND sky130_ef_sc_hd__decap_12
XFILLER_51_530 VPWR VGND VPWR VGND sky130_ef_sc_hd__decap_12
XFILLER_11_416 VGND VGND VPWR VPWR sky130_fd_sc_hd__fill_1
XFILLER_23_298 VPWR VGND VPWR VGND sky130_ef_sc_hd__decap_12
XTAP_TAPCELL_ROW_98_1310 VGND VPWR sky130_fd_sc_hd__tapvpwrvgnd_1
XFILLER_23_57 VPWR VGND VPWR VGND sky130_ef_sc_hd__decap_12
XTAP_TAPCELL_ROW_21_466 VGND VPWR sky130_fd_sc_hd__tapvpwrvgnd_1
XFILLER_99_39 VPWR VGND VPWR VGND sky130_ef_sc_hd__decap_12
XFILLER_3_615 VGND VGND VPWR VPWR sky130_fd_sc_hd__fill_1
XPHY_EDGE_ROW_92_Left_200 VGND VGND VPWR VPWR sky130_fd_sc_hd__decap_3
XFILLER_19_505 VGND VGND VPWR VPWR sky130_fd_sc_hd__decap_6
XFILLER_48_65 VGND VGND VPWR VPWR sky130_fd_sc_hd__decap_8
XTAP_TAPCELL_ROW_29_555 VGND VPWR sky130_fd_sc_hd__tapvpwrvgnd_1
XTAP_TAPCELL_ROW_57_864 VGND VPWR sky130_fd_sc_hd__tapvpwrvgnd_1
XFILLER_64_53 VPWR VGND VPWR VGND sky130_ef_sc_hd__decap_12
XFILLER_14_232 VGND VGND VPWR VPWR sky130_fd_sc_hd__fill_1
XFILLER_9_15 VPWR VGND VPWR VGND sky130_ef_sc_hd__decap_12
XFILLER_42_574 VGND VGND VPWR VPWR sky130_fd_sc_hd__fill_1
XTAP_TAPCELL_ROW_103_1369 VGND VPWR sky130_fd_sc_hd__tapvpwrvgnd_1
XFILLER_80_41 VPWR VGND VPWR VGND sky130_ef_sc_hd__decap_12
Xfanout80 fanout86/X VGND VGND VPWR VPWR _4331_/A2 sky130_fd_sc_hd__clkbuf_4
Xfanout91 _3813_/A2 VGND VGND VPWR VPWR _3748_/B2 sky130_fd_sc_hd__buf_2
XFILLER_80_85 VGND VGND VPWR VPWR sky130_fd_sc_hd__fill_1
X_2350_ _4363_/Q _4149_/B VGND VGND VPWR VPWR _2352_/A sky130_fd_sc_hd__nand2b_4
XTAP_TAPCELL_ROW_71_1015 VGND VPWR sky130_fd_sc_hd__tapvpwrvgnd_1
X_2281_ _4704_/Q _2495_/A _4703_/Q _2214_/Y VGND VGND VPWR VPWR _2281_/X sky130_fd_sc_hd__a22o_1
X_4020_ _4730_/Q _4030_/B VGND VGND VPWR VPWR _4020_/X sky130_fd_sc_hd__and2_2
Xclkbuf_leaf_1_clk clkload0/A VGND VGND VPWR VPWR clkload7/A sky130_fd_sc_hd__clkbuf_8
XFILLER_80_625 VPWR VGND VPWR VGND sky130_ef_sc_hd__decap_12
XFILLER_64_154 VPWR VGND VPWR VGND sky130_ef_sc_hd__decap_12
XTAP_TAPCELL_ROW_82_1133 VGND VPWR sky130_fd_sc_hd__tapvpwrvgnd_1
XFILLER_100_29 VPWR VGND VPWR VGND sky130_ef_sc_hd__decap_12
X_3804_ _3805_/A _3805_/B VGND VGND VPWR VPWR _3806_/A sky130_fd_sc_hd__or2_1
X_3735_ _3735_/A _3735_/B VGND VGND VPWR VPWR _3735_/Y sky130_fd_sc_hd__nand2_1
XFILLER_106_307 VGND VGND VPWR VPWR sky130_fd_sc_hd__fill_1
Xclkload50 _4715_/CLK VGND VGND VPWR VPWR clkload50/Y sky130_fd_sc_hd__inv_6
X_3666_ _4754_/Q _3667_/B VGND VGND VPWR VPWR _3723_/C sky130_fd_sc_hd__or2_1
XTAP_TAPCELL_ROW_93_1251 VGND VPWR sky130_fd_sc_hd__tapvpwrvgnd_1
X_2617_ _2617_/A _2617_/B VGND VGND VPWR VPWR _2618_/B sky130_fd_sc_hd__xnor2_1
X_3597_ _4751_/Q _3597_/B VGND VGND VPWR VPWR _3598_/B sky130_fd_sc_hd__nor2_1
XFILLER_102_513 VPWR VGND VPWR VGND sky130_ef_sc_hd__decap_12
XFILLER_0_629 VGND VGND VPWR VPWR sky130_fd_sc_hd__decap_3
X_2548_ _4477_/Q _2550_/C VGND VGND VPWR VPWR _2548_/X sky130_fd_sc_hd__or2_1
XFILLER_102_557 VPWR VGND VPWR VGND sky130_ef_sc_hd__decap_12
X_2479_ _2481_/B VGND VGND VPWR VPWR _2479_/Y sky130_fd_sc_hd__inv_2
X_4218_ _4703_/Q _4218_/B VGND VGND VPWR VPWR _4222_/B sky130_fd_sc_hd__and2_1
X_4149_ _4363_/Q _4149_/B VGND VGND VPWR VPWR _4149_/Y sky130_fd_sc_hd__nand2_2
XFILLER_83_485 VPWR VGND VPWR VGND sky130_ef_sc_hd__decap_12
XFILLER_70_124 VGND VGND VPWR VPWR sky130_fd_sc_hd__fill_2
XTAP_TAPCELL_ROW_26_514 VGND VPWR sky130_fd_sc_hd__tapvpwrvgnd_1
XTAP_TAPCELL_ROW_54_823 VGND VPWR sky130_fd_sc_hd__tapvpwrvgnd_1
XFILLER_55_198 VGND VGND VPWR VPWR sky130_fd_sc_hd__fill_1
XFILLER_70_157 VGND VGND VPWR VPWR sky130_fd_sc_hd__decap_6
XFILLER_24_541 VGND VGND VPWR VPWR sky130_fd_sc_hd__fill_2
XFILLER_24_585 VGND VGND VPWR VPWR sky130_fd_sc_hd__decap_3
XFILLER_24_596 VGND VGND VPWR VPWR sky130_fd_sc_hd__fill_1
XFILLER_51_382 VGND VGND VPWR VPWR sky130_fd_sc_hd__decap_4
Xclkload0 clkload0/A VGND VGND VPWR VPWR clkload0/Y sky130_fd_sc_hd__clkinv_2
XFILLER_50_77 VGND VGND VPWR VPWR sky130_fd_sc_hd__decap_6
XFILLER_3_434 VPWR VGND VPWR VGND sky130_ef_sc_hd__decap_12
XFILLER_78_202 VGND VGND VPWR VPWR sky130_fd_sc_hd__decap_4
XFILLER_105_373 VPWR VGND VPWR VGND sky130_ef_sc_hd__decap_12
XFILLER_78_235 VGND VGND VPWR VPWR sky130_fd_sc_hd__decap_4
XFILLER_93_216 VGND VGND VPWR VPWR sky130_fd_sc_hd__decap_8
XFILLER_78_279 VGND VGND VPWR VPWR sky130_fd_sc_hd__decap_3
XTAP_TAPCELL_ROW_6_294 VGND VPWR sky130_fd_sc_hd__tapvpwrvgnd_1
XFILLER_19_313 VGND VGND VPWR VPWR sky130_fd_sc_hd__fill_2
XFILLER_59_493 VGND VGND VPWR VPWR sky130_fd_sc_hd__decap_8
XFILLER_62_625 VPWR VGND VPWR VGND sky130_ef_sc_hd__decap_12
XFILLER_61_113 VGND VGND VPWR VPWR sky130_fd_sc_hd__decap_6
XFILLER_91_51 VGND VGND VPWR VPWR sky130_fd_sc_hd__decap_4
XFILLER_15_596 VGND VGND VPWR VPWR sky130_fd_sc_hd__decap_3
XFILLER_30_599 VGND VGND VPWR VPWR sky130_fd_sc_hd__fill_2
X_3520_ _3599_/S0 _3520_/B VGND VGND VPWR VPWR _3520_/X sky130_fd_sc_hd__and2b_1
XFILLER_6_283 VGND VGND VPWR VPWR sky130_fd_sc_hd__decap_4
X_3451_ _3451_/A _3676_/A VGND VGND VPWR VPWR _3453_/B sky130_fd_sc_hd__xnor2_1
X_3382_ _3382_/A _3382_/B _3382_/C VGND VGND VPWR VPWR _3382_/X sky130_fd_sc_hd__or3_1
X_2402_ hold23/X _2407_/A2 _2407_/B1 _4503_/Q VGND VGND VPWR VPWR hold24/A sky130_fd_sc_hd__a22o_1
XFILLER_41_3 VPWR VGND VPWR VGND sky130_ef_sc_hd__decap_12
X_2333_ input6/X _4718_/D VGND VGND VPWR VPWR _4732_/D sky130_fd_sc_hd__and2_1
XFILLER_69_279 VGND VGND VPWR VPWR sky130_fd_sc_hd__fill_1
X_2264_ _4714_/Q _2529_/A _4713_/Q _2203_/Y VGND VGND VPWR VPWR _2265_/A sky130_fd_sc_hd__o22a_1
X_4003_ hold122/X _4731_/Q _4007_/S VGND VGND VPWR VPWR _4560_/D sky130_fd_sc_hd__mux2_1
X_2195_ _4450_/Q VGND VGND VPWR VPWR _2461_/A sky130_fd_sc_hd__inv_2
XFILLER_65_485 VPWR VGND VPWR VGND sky130_ef_sc_hd__decap_12
XFILLER_1_93 VPWR VGND VPWR VGND sky130_ef_sc_hd__decap_12
XFILLER_80_477 VPWR VGND VPWR VGND sky130_ef_sc_hd__decap_12
X_4767_ _4767_/CLK _4767_/D fanout144/X VGND VGND VPWR VPWR _4767_/Q sky130_fd_sc_hd__dfrtp_1
XTAP_TAPCELL_ROW_31_572 VGND VPWR sky130_fd_sc_hd__tapvpwrvgnd_1
X_3718_ _4540_/Q _3718_/B _3718_/C VGND VGND VPWR VPWR _3718_/X sky130_fd_sc_hd__or3_1
X_4698_ _4724_/CLK _4698_/D fanout159/X VGND VGND VPWR VPWR hold79/A sky130_fd_sc_hd__dfrtp_1
X_3649_ _3650_/A _3650_/B VGND VGND VPWR VPWR _3649_/X sky130_fd_sc_hd__and2_1
XFILLER_102_321 VPWR VGND VPWR VGND sky130_ef_sc_hd__decap_12
XFILLER_96_29 VPWR VGND VPWR VGND sky130_ef_sc_hd__decap_12
XFILLER_88_533 VPWR VGND VPWR VGND sky130_ef_sc_hd__decap_12
Xhold12 hold12/A VGND VGND VPWR VPWR hold12/X sky130_fd_sc_hd__dlygate4sd3_1
Xhold23 hold23/A VGND VGND VPWR VPWR hold23/X sky130_fd_sc_hd__dlygate4sd3_1
XFILLER_102_365 VPWR VGND VPWR VGND sky130_ef_sc_hd__decap_12
Xhold45 hold45/A VGND VGND VPWR VPWR hold45/X sky130_fd_sc_hd__dlygate4sd3_1
XFILLER_29_611 VGND VGND VPWR VPWR sky130_fd_sc_hd__fill_1
Xhold34 hold34/A VGND VGND VPWR VPWR hold34/X sky130_fd_sc_hd__dlygate4sd3_1
Xhold56 hold56/A VGND VGND VPWR VPWR hold56/X sky130_fd_sc_hd__dlygate4sd3_1
XFILLER_48_419 VGND VGND VPWR VPWR sky130_fd_sc_hd__fill_1
XFILLER_29_633 VGND VGND VPWR VPWR sky130_fd_sc_hd__fill_1
Xhold78 hold78/A VGND VGND VPWR VPWR hold78/X sky130_fd_sc_hd__dlygate4sd3_1
Xhold67 hold67/A VGND VGND VPWR VPWR hold67/X sky130_fd_sc_hd__dlygate4sd3_1
Xhold89 hold89/A VGND VGND VPWR VPWR hold89/X sky130_fd_sc_hd__dlygate4sd3_1
XFILLER_90_219 VPWR VGND VPWR VGND sky130_ef_sc_hd__decap_12
XFILLER_90_208 VGND VGND VPWR VPWR sky130_fd_sc_hd__decap_8
XTAP_TAPCELL_ROW_67_970 VGND VPWR sky130_fd_sc_hd__tapvpwrvgnd_1
XPHY_EDGE_ROW_11_Left_119 VGND VGND VPWR VPWR sky130_fd_sc_hd__decap_3
XTAP_TAPCELL_ROW_3_264 VGND VPWR sky130_fd_sc_hd__tapvpwrvgnd_1
XTAP_TAPCELL_ROW_39_661 VGND VPWR sky130_fd_sc_hd__tapvpwrvgnd_1
XFILLER_83_293 VGND VGND VPWR VPWR sky130_fd_sc_hd__decap_8
XFILLER_71_422 VGND VGND VPWR VPWR sky130_fd_sc_hd__fill_1
XFILLER_43_113 VGND VGND VPWR VPWR sky130_fd_sc_hd__decap_3
XFILLER_45_55 VGND VGND VPWR VPWR sky130_fd_sc_hd__fill_1
XFILLER_24_371 VGND VGND VPWR VPWR sky130_fd_sc_hd__decap_6
XFILLER_31_319 VGND VGND VPWR VPWR sky130_fd_sc_hd__decap_4
XTAP_TAPCELL_ROW_100_1328 VGND VPWR sky130_fd_sc_hd__tapvpwrvgnd_1
XFILLER_12_533 VGND VGND VPWR VPWR sky130_fd_sc_hd__decap_6
XFILLER_6_27 VGND VGND VPWR VPWR sky130_fd_sc_hd__fill_1
XPHY_EDGE_ROW_20_Left_128 VGND VGND VPWR VPWR sky130_fd_sc_hd__decap_3
XFILLER_105_181 VPWR VGND VPWR VGND sky130_ef_sc_hd__decap_12
XFILLER_94_525 VGND VGND VPWR VPWR sky130_fd_sc_hd__decap_6
XFILLER_94_569 VPWR VGND VPWR VGND sky130_ef_sc_hd__decap_12
XFILLER_81_219 VGND VGND VPWR VPWR sky130_fd_sc_hd__decap_4
XFILLER_19_165 VGND VGND VPWR VPWR sky130_fd_sc_hd__decap_3
XFILLER_35_614 VGND VGND VPWR VPWR sky130_fd_sc_hd__fill_2
XFILLER_62_477 VPWR VGND VPWR VGND sky130_ef_sc_hd__decap_12
X_2951_ _4507_/Q _2952_/B VGND VGND VPWR VPWR _2953_/A sky130_fd_sc_hd__and2_1
XFILLER_89_3 VPWR VGND VPWR VGND sky130_ef_sc_hd__decap_12
X_4621_ _4656_/CLK _4621_/D fanout120/X VGND VGND VPWR VPWR _4621_/Q sky130_fd_sc_hd__dfrtp_1
XFILLER_30_363 VGND VGND VPWR VPWR sky130_fd_sc_hd__fill_1
X_2882_ _2865_/A _2865_/B _2862_/A VGND VGND VPWR VPWR _2892_/A sky130_fd_sc_hd__o21ai_1
XFILLER_30_396 VGND VGND VPWR VPWR sky130_fd_sc_hd__decap_8
X_4552_ _4552_/CLK _4552_/D fanout170/X VGND VGND VPWR VPWR _4552_/Q sky130_fd_sc_hd__dfrtp_4
X_4483_ _4734_/CLK _4483_/D fanout148/X VGND VGND VPWR VPWR _4483_/Q sky130_fd_sc_hd__dfrtp_1
XFILLER_7_570 VGND VGND VPWR VPWR sky130_fd_sc_hd__decap_4
X_3503_ _3517_/A VGND VGND VPWR VPWR _3503_/Y sky130_fd_sc_hd__inv_2
XTAP_TAPCELL_ROW_77_1076 VGND VPWR sky130_fd_sc_hd__tapvpwrvgnd_1
X_3434_ _3434_/A _3434_/B VGND VGND VPWR VPWR _3436_/B sky130_fd_sc_hd__xnor2_2
XTAP_TAPCELL_ROW_90_1221 VGND VPWR sky130_fd_sc_hd__tapvpwrvgnd_1
X_3365_ _3366_/B _3366_/C _3366_/A VGND VGND VPWR VPWR _3368_/B sky130_fd_sc_hd__a21o_1
XFILLER_97_385 VGND VGND VPWR VPWR sky130_fd_sc_hd__decap_6
XFILLER_85_503 VGND VGND VPWR VPWR sky130_fd_sc_hd__fill_1
X_3296_ _4523_/Q _3296_/B VGND VGND VPWR VPWR _3298_/B sky130_fd_sc_hd__xnor2_1
X_2316_ _2278_/X _2316_/B _2316_/C _2316_/D VGND VGND VPWR VPWR _2316_/X sky130_fd_sc_hd__and4b_1
X_2247_ hold58/A _2245_/B _4770_/Q _4368_/Q VGND VGND VPWR VPWR _2247_/X sky130_fd_sc_hd__a22o_1
XFILLER_26_614 VGND VGND VPWR VPWR sky130_fd_sc_hd__decap_4
XTAP_TAPCELL_ROW_0_223 VGND VPWR sky130_fd_sc_hd__tapvpwrvgnd_1
XTAP_TAPCELL_ROW_0_234 VGND VPWR sky130_fd_sc_hd__tapvpwrvgnd_1
X_2178_ _4370_/Q VGND VGND VPWR VPWR _2245_/B sky130_fd_sc_hd__inv_2
XFILLER_80_241 VGND VGND VPWR VPWR sky130_fd_sc_hd__decap_8
XTAP_TAPCELL_ROW_64_940 VGND VPWR sky130_fd_sc_hd__tapvpwrvgnd_1
XTAP_TAPCELL_ROW_36_631 VGND VPWR sky130_fd_sc_hd__tapvpwrvgnd_1
XFILLER_41_606 VGND VGND VPWR VPWR sky130_fd_sc_hd__fill_1
XFILLER_41_617 VGND VGND VPWR VPWR sky130_fd_sc_hd__decap_8
XFILLER_15_69 VPWR VGND VPWR VGND sky130_ef_sc_hd__decap_12
XFILLER_21_396 VGND VGND VPWR VPWR sky130_fd_sc_hd__fill_1
XFILLER_31_57 VPWR VGND VPWR VGND sky130_ef_sc_hd__decap_12
XTAP_TAPCELL_ROW_8_323 VGND VPWR sky130_fd_sc_hd__tapvpwrvgnd_1
XFILLER_88_330 VGND VGND VPWR VPWR sky130_fd_sc_hd__decap_6
XFILLER_76_525 VGND VGND VPWR VPWR sky130_fd_sc_hd__decap_6
XFILLER_102_195 VGND VGND VPWR VPWR sky130_fd_sc_hd__fill_1
XFILLER_76_569 VPWR VGND VPWR VGND sky130_ef_sc_hd__decap_12
XFILLER_91_517 VPWR VGND VPWR VGND sky130_ef_sc_hd__decap_12
XFILLER_56_65 VPWR VGND VPWR VGND sky130_ef_sc_hd__decap_12
XFILLER_17_614 VGND VGND VPWR VPWR sky130_fd_sc_hd__fill_2
XPHY_EDGE_ROW_19_Right_19 VGND VGND VPWR VPWR sky130_fd_sc_hd__decap_3
XFILLER_72_53 VPWR VGND VPWR VGND sky130_ef_sc_hd__decap_12
XFILLER_71_263 VGND VGND VPWR VPWR sky130_fd_sc_hd__fill_1
XFILLER_16_168 VGND VGND VPWR VPWR sky130_fd_sc_hd__decap_4
XFILLER_44_477 VPWR VGND VPWR VGND sky130_ef_sc_hd__decap_12
XFILLER_31_127 VPWR VGND VPWR VGND sky130_ef_sc_hd__decap_12
XTAP_TAPCELL_ROW_70_998 VGND VPWR sky130_fd_sc_hd__tapvpwrvgnd_1
XFILLER_8_301 VGND VGND VPWR VPWR sky130_fd_sc_hd__decap_6
XTAP_TAPCELL_ROW_42_689 VGND VPWR sky130_fd_sc_hd__tapvpwrvgnd_1
XFILLER_8_378 VGND VGND VPWR VPWR sky130_fd_sc_hd__decap_4
Xclkbuf_3_1__f_clk clkbuf_0_clk/X VGND VGND VPWR VPWR clkload1/A sky130_fd_sc_hd__clkbuf_16
XFILLER_99_617 VPWR VGND VPWR VGND sky130_ef_sc_hd__decap_12
XPHY_EDGE_ROW_28_Right_28 VGND VGND VPWR VPWR sky130_fd_sc_hd__decap_3
X_3150_ _3128_/A _3128_/B _3127_/A VGND VGND VPWR VPWR _3151_/B sky130_fd_sc_hd__a21bo_1
XFILLER_39_216 VGND VGND VPWR VPWR sky130_fd_sc_hd__fill_1
X_3081_ _4512_/Q _3081_/A2 _3880_/A _4345_/B2 VGND VGND VPWR VPWR _4512_/D sky130_fd_sc_hd__a22o_1
XFILLER_94_377 VPWR VGND VPWR VGND sky130_ef_sc_hd__decap_12
XPHY_EDGE_ROW_37_Right_37 VGND VGND VPWR VPWR sky130_fd_sc_hd__decap_3
XFILLER_50_403 VGND VGND VPWR VPWR sky130_fd_sc_hd__fill_1
X_3983_ _4652_/Q _4588_/Q hold97/A hold51/A _3983_/S0 _3983_/S1 VGND VGND VPWR VPWR
+ _3985_/A sky130_fd_sc_hd__mux4_1
XFILLER_50_447 VGND VGND VPWR VPWR sky130_fd_sc_hd__decap_8
X_2934_ _3634_/A VGND VGND VPWR VPWR _3737_/A sky130_fd_sc_hd__inv_2
XTAP_TAPCELL_ROW_79_1105 VGND VPWR sky130_fd_sc_hd__tapvpwrvgnd_1
X_2865_ _2865_/A _2865_/B VGND VGND VPWR VPWR _2874_/A sky130_fd_sc_hd__xnor2_1
XTAP_TAPCELL_ROW_13_380 VGND VPWR sky130_fd_sc_hd__tapvpwrvgnd_1
XPHY_EDGE_ROW_46_Right_46 VGND VGND VPWR VPWR sky130_fd_sc_hd__decap_3
X_4604_ _4752_/CLK _4604_/D fanout136/X VGND VGND VPWR VPWR _4604_/Q sky130_fd_sc_hd__dfrtp_1
Xhold301 _4494_/Q VGND VGND VPWR VPWR hold301/X sky130_fd_sc_hd__dlygate4sd3_1
XFILLER_7_81 VPWR VGND VPWR VGND sky130_ef_sc_hd__decap_12
X_2796_ _2796_/A _2807_/B VGND VGND VPWR VPWR _2798_/A sky130_fd_sc_hd__xnor2_2
X_4535_ _4536_/CLK _4535_/D fanout154/X VGND VGND VPWR VPWR _4535_/Q sky130_fd_sc_hd__dfrtp_4
X_4466_ _4708_/CLK _4466_/D fanout164/X VGND VGND VPWR VPWR _4466_/Q sky130_fd_sc_hd__dfrtp_2
X_3417_ _3417_/A _3633_/A VGND VGND VPWR VPWR _3419_/B sky130_fd_sc_hd__xnor2_1
X_4397_ _4538_/CLK _4397_/D fanout167/X VGND VGND VPWR VPWR _4397_/Q sky130_fd_sc_hd__dfrtp_1
XFILLER_85_300 VPWR VGND VPWR VGND sky130_ef_sc_hd__decap_12
X_3348_ _3272_/A _3348_/B _3348_/C VGND VGND VPWR VPWR _3351_/B sky130_fd_sc_hd__nand3b_1
XFILLER_58_525 VGND VGND VPWR VPWR sky130_fd_sc_hd__decap_6
XFILLER_97_193 VPWR VGND VPWR VGND sky130_ef_sc_hd__decap_12
XFILLER_73_517 VPWR VGND VPWR VGND sky130_ef_sc_hd__decap_12
X_3279_ _3300_/B _3279_/B VGND VGND VPWR VPWR _3287_/A sky130_fd_sc_hd__and2_1
XPHY_EDGE_ROW_55_Right_55 VGND VGND VPWR VPWR sky130_fd_sc_hd__decap_3
XFILLER_58_569 VPWR VGND VPWR VGND sky130_ef_sc_hd__decap_12
XFILLER_45_219 VGND VGND VPWR VPWR sky130_fd_sc_hd__decap_4
XFILLER_26_433 VGND VGND VPWR VPWR sky130_fd_sc_hd__fill_1
XFILLER_81_561 VPWR VGND VPWR VGND sky130_ef_sc_hd__decap_12
XFILLER_26_466 VGND VGND VPWR VPWR sky130_fd_sc_hd__decap_8
XFILLER_53_252 VGND VGND VPWR VPWR sky130_fd_sc_hd__fill_1
XFILLER_41_447 VGND VGND VPWR VPWR sky130_fd_sc_hd__fill_1
XPHY_EDGE_ROW_64_Right_64 VGND VGND VPWR VPWR sky130_fd_sc_hd__decap_3
XFILLER_5_304 VGND VGND VPWR VPWR sky130_fd_sc_hd__fill_2
XFILLER_5_337 VGND VGND VPWR VPWR sky130_fd_sc_hd__decap_6
XFILLER_107_265 VPWR VGND VPWR VGND sky130_ef_sc_hd__decap_12
XFILLER_3_39 VPWR VGND VPWR VGND sky130_ef_sc_hd__decap_12
XFILLER_76_322 VPWR VGND VPWR VGND sky130_ef_sc_hd__decap_12
XPHY_EDGE_ROW_73_Right_73 VGND VGND VPWR VPWR sky130_fd_sc_hd__decap_3
XFILLER_49_536 VGND VGND VPWR VPWR sky130_fd_sc_hd__decap_4
XFILLER_49_569 VGND VGND VPWR VPWR sky130_fd_sc_hd__fill_1
XPHY_EDGE_ROW_103_Left_211 VGND VGND VPWR VPWR sky130_fd_sc_hd__decap_3
XTAP_TAPCELL_ROW_19_439 VGND VPWR sky130_fd_sc_hd__tapvpwrvgnd_1
XTAP_TAPCELL_ROW_47_748 VGND VPWR sky130_fd_sc_hd__tapvpwrvgnd_1
XFILLER_17_499 VGND VGND VPWR VPWR sky130_fd_sc_hd__decap_4
XFILLER_44_285 VPWR VGND VPWR VGND sky130_ef_sc_hd__decap_12
XPHY_EDGE_ROW_82_Right_82 VGND VGND VPWR VPWR sky130_fd_sc_hd__decap_3
XFILLER_8_153 VGND VGND VPWR VPWR sky130_fd_sc_hd__fill_1
X_2650_ _4562_/Q _4594_/Q _4626_/Q _4658_/Q _3257_/A _2747_/A VGND VGND VPWR VPWR
+ _2652_/B sky130_fd_sc_hd__mux4_1
XFILLER_8_197 VGND VGND VPWR VPWR sky130_fd_sc_hd__fill_2
X_2581_ _2581_/A _2581_/B VGND VGND VPWR VPWR _2585_/A sky130_fd_sc_hd__xor2_1
XTAP_TAPCELL_ROW_74_1046 VGND VPWR sky130_fd_sc_hd__tapvpwrvgnd_1
X_4320_ _4320_/A VGND VGND VPWR VPWR _4320_/Y sky130_fd_sc_hd__inv_2
XFILLER_99_447 VGND VGND VPWR VPWR sky130_fd_sc_hd__fill_1
XFILLER_87_609 VGND VGND VPWR VPWR sky130_fd_sc_hd__decap_6
X_4251_ _4712_/Q _4254_/C _4265_/B VGND VGND VPWR VPWR _4251_/Y sky130_fd_sc_hd__o21ai_1
XPHY_EDGE_ROW_91_Right_91 VGND VGND VPWR VPWR sky130_fd_sc_hd__decap_3
X_3202_ _3185_/A _3184_/A _3184_/B VGND VGND VPWR VPWR _3203_/B sky130_fd_sc_hd__a21bo_1
X_4182_ _4213_/A1 _4180_/Y _4181_/X _4217_/B1 hold261/X VGND VGND VPWR VPWR _4692_/D
+ sky130_fd_sc_hd__a32o_1
XFILLER_94_141 VPWR VGND VPWR VGND sky130_ef_sc_hd__decap_12
X_3133_ _4761_/Q _3133_/B VGND VGND VPWR VPWR _3134_/B sky130_fd_sc_hd__or2_1
XFILLER_82_325 VGND VGND VPWR VPWR sky130_fd_sc_hd__fill_1
X_3064_ _3064_/A _3064_/B VGND VGND VPWR VPWR _3072_/A sky130_fd_sc_hd__xnor2_1
XFILLER_82_358 VGND VGND VPWR VPWR sky130_fd_sc_hd__decap_6
XTAP_TAPCELL_ROW_85_1164 VGND VPWR sky130_fd_sc_hd__tapvpwrvgnd_1
XFILLER_63_561 VPWR VGND VPWR VGND sky130_ef_sc_hd__decap_12
XFILLER_35_241 VGND VGND VPWR VPWR sky130_fd_sc_hd__fill_1
X_3966_ _3967_/A _3967_/B VGND VGND VPWR VPWR _3968_/A sky130_fd_sc_hd__and2_1
X_2917_ _2869_/A _2891_/B _2891_/A VGND VGND VPWR VPWR _2917_/X sky130_fd_sc_hd__o21ba_1
X_3897_ _3897_/A _3897_/B VGND VGND VPWR VPWR _3900_/A sky130_fd_sc_hd__xnor2_2
XFILLER_12_15 VPWR VGND VPWR VGND sky130_ef_sc_hd__decap_12
X_2848_ _2919_/A _2824_/B _2818_/A VGND VGND VPWR VPWR _2849_/B sky130_fd_sc_hd__o21ai_1
X_2779_ _2831_/B VGND VGND VPWR VPWR _2782_/B sky130_fd_sc_hd__inv_2
XTAP_TAPCELL_ROW_96_1293 VGND VPWR sky130_fd_sc_hd__tapvpwrvgnd_1
X_4518_ _4519_/CLK _4518_/D fanout170/X VGND VGND VPWR VPWR _4518_/Q sky130_fd_sc_hd__dfrtp_1
Xhold142 _4580_/Q VGND VGND VPWR VPWR hold142/X sky130_fd_sc_hd__dlygate4sd3_1
Xhold131 _4611_/Q VGND VGND VPWR VPWR hold131/X sky130_fd_sc_hd__dlygate4sd3_1
Xhold120 _4676_/Q VGND VGND VPWR VPWR hold120/X sky130_fd_sc_hd__dlygate4sd3_1
Xhold153 _4605_/Q VGND VGND VPWR VPWR hold153/X sky130_fd_sc_hd__dlygate4sd3_1
Xhold175 _4486_/Q VGND VGND VPWR VPWR hold175/X sky130_fd_sc_hd__dlygate4sd3_1
X_4449_ _4721_/CLK _4449_/D fanout158/X VGND VGND VPWR VPWR hold85/A sky130_fd_sc_hd__dfrtp_1
Xhold186 _4602_/Q VGND VGND VPWR VPWR hold186/X sky130_fd_sc_hd__dlygate4sd3_1
Xhold164 _4606_/Q VGND VGND VPWR VPWR hold164/X sky130_fd_sc_hd__dlygate4sd3_1
Xhold197 _4595_/Q VGND VGND VPWR VPWR hold197/X sky130_fd_sc_hd__dlygate4sd3_1
XFILLER_85_152 VGND VGND VPWR VPWR sky130_fd_sc_hd__decap_4
XFILLER_14_414 VGND VGND VPWR VPWR sky130_fd_sc_hd__decap_6
XTAP_TAPCELL_ROW_16_409 VGND VPWR sky130_fd_sc_hd__tapvpwrvgnd_1
XTAP_TAPCELL_ROW_44_718 VGND VPWR sky130_fd_sc_hd__tapvpwrvgnd_1
XFILLER_41_266 VGND VGND VPWR VPWR sky130_fd_sc_hd__decap_3
XFILLER_53_55 VGND VGND VPWR VPWR sky130_fd_sc_hd__fill_1
XFILLER_6_602 VGND VGND VPWR VPWR sky130_fd_sc_hd__decap_6
XTAP_TAPCELL_ROW_24_497 VGND VPWR sky130_fd_sc_hd__tapvpwrvgnd_1
XFILLER_6_613 VPWR VGND VPWR VGND sky130_ef_sc_hd__decap_12
XFILLER_78_41 VPWR VGND VPWR VGND sky130_ef_sc_hd__decap_12
XFILLER_69_609 VGND VGND VPWR VPWR sky130_fd_sc_hd__decap_6
XFILLER_78_85 VGND VGND VPWR VPWR sky130_fd_sc_hd__fill_1
XFILLER_68_108 VGND VGND VPWR VPWR sky130_fd_sc_hd__fill_1
XFILLER_49_333 VGND VGND VPWR VPWR sky130_fd_sc_hd__decap_3
XFILLER_92_601 VPWR VGND VPWR VGND sky130_ef_sc_hd__decap_12
XFILLER_91_122 VGND VGND VPWR VPWR sky130_fd_sc_hd__decap_4
XFILLER_17_263 VGND VGND VPWR VPWR sky130_fd_sc_hd__decap_3
XFILLER_60_531 VGND VGND VPWR VPWR sky130_fd_sc_hd__fill_1
XFILLER_17_296 VGND VGND VPWR VPWR sky130_fd_sc_hd__fill_2
X_3820_ _3820_/A _3820_/B VGND VGND VPWR VPWR _3822_/D sky130_fd_sc_hd__nand2_1
X_3751_ _3751_/A _3967_/A VGND VGND VPWR VPWR _3753_/B sky130_fd_sc_hd__xnor2_1
X_2702_ _2702_/A _2702_/B VGND VGND VPWR VPWR _2703_/B sky130_fd_sc_hd__xnor2_1
XFILLER_71_3 VPWR VGND VPWR VGND sky130_ef_sc_hd__decap_12
X_3682_ _3636_/X _3681_/X _3649_/X VGND VGND VPWR VPWR _3683_/B sky130_fd_sc_hd__a21oi_1
X_2633_ _2711_/A _2633_/B VGND VGND VPWR VPWR _2640_/A sky130_fd_sc_hd__xnor2_1
X_2564_ hold218/X _4733_/Q _2566_/S VGND VGND VPWR VPWR _4487_/D sky130_fd_sc_hd__mux2_1
X_4303_ hold42/A hold26/A hold13/A _4401_/Q _2427_/A _2427_/B VGND VGND VPWR VPWR
+ _4304_/B sky130_fd_sc_hd__mux4_1
XFILLER_101_205 VPWR VGND VPWR VGND sky130_ef_sc_hd__decap_12
X_2495_ _2495_/A _2495_/B VGND VGND VPWR VPWR _2501_/C sky130_fd_sc_hd__nor2_1
X_4234_ _4238_/A1 _4232_/X _4233_/Y _4238_/B1 hold280/X VGND VGND VPWR VPWR _4707_/D
+ sky130_fd_sc_hd__a32o_1
XFILLER_101_249 VPWR VGND VPWR VGND sky130_ef_sc_hd__decap_12
X_4165_ _4206_/A1 _4163_/Y _4164_/X _4206_/B1 hold273/X VGND VGND VPWR VPWR _4687_/D
+ sky130_fd_sc_hd__a32o_1
XFILLER_95_461 VPWR VGND VPWR VGND sky130_ef_sc_hd__decap_12
X_3116_ _4542_/Q _4551_/Q VGND VGND VPWR VPWR _3119_/B sky130_fd_sc_hd__xor2_1
X_4096_ _4132_/A1 _4013_/B _4016_/B _4094_/Y hold100/X VGND VGND VPWR VPWR _4629_/D
+ sky130_fd_sc_hd__a32o_1
X_3047_ _3047_/A VGND VGND VPWR VPWR _3049_/A sky130_fd_sc_hd__inv_2
XFILLER_63_391 VGND VGND VPWR VPWR sky130_fd_sc_hd__fill_1
XFILLER_23_200 VGND VGND VPWR VPWR sky130_fd_sc_hd__decap_6
XFILLER_23_222 VGND VGND VPWR VPWR sky130_fd_sc_hd__fill_2
XFILLER_51_542 VPWR VGND VPWR VGND sky130_ef_sc_hd__decap_12
XTAP_TAPCELL_ROW_98_1311 VGND VPWR sky130_fd_sc_hd__tapvpwrvgnd_1
X_3949_ _3921_/Y _3925_/B _3923_/B VGND VGND VPWR VPWR _3950_/B sky130_fd_sc_hd__o21a_1
XFILLER_23_69 VPWR VGND VPWR VGND sky130_ef_sc_hd__decap_12
XTAP_TAPCELL_ROW_21_467 VGND VPWR sky130_fd_sc_hd__tapvpwrvgnd_1
XFILLER_2_159 VGND VGND VPWR VPWR sky130_fd_sc_hd__decap_8
XFILLER_58_141 VGND VGND VPWR VPWR sky130_fd_sc_hd__decap_4
XFILLER_74_601 VPWR VGND VPWR VGND sky130_ef_sc_hd__decap_12
XFILLER_48_77 VGND VGND VPWR VPWR sky130_fd_sc_hd__decap_4
XFILLER_73_122 VGND VGND VPWR VPWR sky130_fd_sc_hd__decap_3
XFILLER_0_29 VPWR VGND VPWR VGND sky130_ef_sc_hd__decap_12
XTAP_TAPCELL_ROW_57_854 VGND VPWR sky130_fd_sc_hd__tapvpwrvgnd_1
XFILLER_104_83 VGND VGND VPWR VPWR sky130_fd_sc_hd__fill_1
XTAP_TAPCELL_ROW_29_556 VGND VPWR sky130_fd_sc_hd__tapvpwrvgnd_1
XFILLER_64_65 VPWR VGND VPWR VGND sky130_ef_sc_hd__decap_12
XFILLER_42_531 VGND VGND VPWR VPWR sky130_fd_sc_hd__fill_1
XFILLER_14_244 VGND VGND VPWR VPWR sky130_fd_sc_hd__fill_1
XFILLER_9_27 VPWR VGND VPWR VGND sky130_ef_sc_hd__decap_12
XFILLER_80_53 VPWR VGND VPWR VGND sky130_ef_sc_hd__decap_12
Xfanout92 _3813_/A2 VGND VGND VPWR VPWR _3979_/B2 sky130_fd_sc_hd__buf_2
Xfanout81 fanout86/X VGND VGND VPWR VPWR _3277_/B2 sky130_fd_sc_hd__clkbuf_2
Xfanout70 _2983_/B2 VGND VGND VPWR VPWR _4331_/B2 sky130_fd_sc_hd__clkbuf_4
XFILLER_10_483 VGND VGND VPWR VPWR sky130_fd_sc_hd__fill_1
XFILLER_89_51 VGND VGND VPWR VPWR sky130_fd_sc_hd__decap_4
XTAP_TAPCELL_ROW_71_1016 VGND VPWR sky130_fd_sc_hd__tapvpwrvgnd_1
X_2280_ _4702_/Q _2488_/A _4701_/Q _2218_/Y VGND VGND VPWR VPWR _2280_/X sky130_fd_sc_hd__a22o_1
XFILLER_77_461 VPWR VGND VPWR VGND sky130_ef_sc_hd__decap_12
XFILLER_92_475 VGND VGND VPWR VPWR sky130_fd_sc_hd__fill_1
XFILLER_64_166 VPWR VGND VPWR VGND sky130_ef_sc_hd__decap_12
XFILLER_45_380 VPWR VGND VPWR VGND sky130_ef_sc_hd__decap_12
XTAP_TAPCELL_ROW_82_1134 VGND VPWR sky130_fd_sc_hd__tapvpwrvgnd_1
X_3803_ _4644_/Q _4580_/Q _4676_/Q _4612_/Q _3983_/S0 _3983_/S1 VGND VGND VPWR VPWR
+ _3805_/B sky130_fd_sc_hd__mux4_1
XFILLER_33_586 VGND VGND VPWR VPWR sky130_fd_sc_hd__decap_3
XFILLER_33_597 VGND VGND VPWR VPWR sky130_fd_sc_hd__decap_3
XFILLER_60_361 VGND VGND VPWR VPWR sky130_fd_sc_hd__decap_3
X_3734_ _3637_/A _3637_/B _3732_/X _3733_/X VGND VGND VPWR VPWR _3740_/A sky130_fd_sc_hd__a211o_1
X_3665_ _3794_/B2 _3663_/Y _3664_/X _3748_/B2 _4539_/Q VGND VGND VPWR VPWR _4539_/D
+ sky130_fd_sc_hd__a32o_1
X_2616_ _2712_/A _2616_/B VGND VGND VPWR VPWR _2617_/B sky130_fd_sc_hd__or2_1
Xclkload40 _4706_/CLK VGND VGND VPWR VPWR clkload40/Y sky130_fd_sc_hd__bufinv_16
Xclkload51 _4538_/CLK VGND VGND VPWR VPWR clkload51/X sky130_fd_sc_hd__clkbuf_8
XTAP_TAPCELL_ROW_93_1252 VGND VPWR sky130_fd_sc_hd__tapvpwrvgnd_1
X_3596_ _4751_/Q _3597_/B VGND VGND VPWR VPWR _3652_/C sky130_fd_sc_hd__and2_1
X_2547_ _4477_/Q _2550_/C VGND VGND VPWR VPWR _2547_/Y sky130_fd_sc_hd__nand2_1
XFILLER_102_525 VGND VGND VPWR VPWR sky130_fd_sc_hd__decap_6
XFILLER_87_225 VPWR VGND VPWR VGND sky130_ef_sc_hd__decap_12
X_2478_ _2478_/A _2478_/B VGND VGND VPWR VPWR _2481_/B sky130_fd_sc_hd__nor2_1
XFILLER_102_569 VPWR VGND VPWR VGND sky130_ef_sc_hd__decap_12
X_4217_ _4238_/A1 _4214_/Y _4216_/Y _4217_/B1 hold215/X VGND VGND VPWR VPWR _4702_/D
+ sky130_fd_sc_hd__a32o_1
XFILLER_68_461 VPWR VGND VPWR VGND sky130_ef_sc_hd__decap_12
XFILLER_28_303 VGND VGND VPWR VPWR sky130_fd_sc_hd__decap_4
XFILLER_56_601 VPWR VGND VPWR VGND sky130_ef_sc_hd__decap_12
X_4148_ hold120/X _4030_/X _4148_/S VGND VGND VPWR VPWR _4676_/D sky130_fd_sc_hd__mux2_1
X_4079_ _4155_/A1 _4013_/Y _4134_/A1 _2352_/A hold38/X VGND VGND VPWR VPWR _4615_/D
+ sky130_fd_sc_hd__a32o_1
XFILLER_71_615 VGND VGND VPWR VPWR sky130_fd_sc_hd__fill_1
XFILLER_83_497 VGND VGND VPWR VPWR sky130_fd_sc_hd__decap_6
XFILLER_70_103 VGND VGND VPWR VPWR sky130_fd_sc_hd__fill_1
XTAP_TAPCELL_ROW_26_515 VGND VPWR sky130_fd_sc_hd__tapvpwrvgnd_1
XTAP_TAPCELL_ROW_54_824 VGND VPWR sky130_fd_sc_hd__tapvpwrvgnd_1
XFILLER_24_564 VGND VGND VPWR VPWR sky130_fd_sc_hd__decap_6
XFILLER_36_391 VGND VGND VPWR VPWR sky130_fd_sc_hd__decap_3
XFILLER_11_236 VGND VGND VPWR VPWR sky130_fd_sc_hd__decap_6
XFILLER_7_207 VGND VGND VPWR VPWR sky130_fd_sc_hd__decap_3
Xclkload1 clkload1/A VGND VGND VPWR VPWR clkload1/Y sky130_fd_sc_hd__inv_8
XFILLER_1_3 VPWR VGND VPWR VGND sky130_ef_sc_hd__decap_12
XFILLER_3_446 VGND VGND VPWR VPWR sky130_fd_sc_hd__fill_2
XFILLER_105_385 VGND VGND VPWR VPWR sky130_fd_sc_hd__decap_6
XFILLER_78_247 VGND VGND VPWR VPWR sky130_fd_sc_hd__fill_1
XTAP_TAPCELL_ROW_6_295 VGND VPWR sky130_fd_sc_hd__tapvpwrvgnd_1
XFILLER_74_475 VGND VGND VPWR VPWR sky130_fd_sc_hd__fill_1
XFILLER_6_295 VGND VGND VPWR VPWR sky130_fd_sc_hd__decap_8
X_3450_ _3442_/A _3525_/A _3441_/A VGND VGND VPWR VPWR _3463_/A sky130_fd_sc_hd__a21o_1
X_3381_ _3380_/B _3380_/C _3380_/A VGND VGND VPWR VPWR _3382_/C sky130_fd_sc_hd__a21oi_1
X_2401_ hold11/X _2408_/A2 _2408_/B1 _4502_/Q VGND VGND VPWR VPWR hold12/A sky130_fd_sc_hd__a22o_1
X_2332_ input5/X _4718_/D VGND VGND VPWR VPWR _4731_/D sky130_fd_sc_hd__and2_1
XFILLER_34_3 VPWR VGND VPWR VGND sky130_ef_sc_hd__decap_12
X_4002_ hold119/X _4730_/Q _4007_/S VGND VGND VPWR VPWR _4559_/D sky130_fd_sc_hd__mux2_1
X_2263_ _4265_/A _4472_/Q _2199_/Y _4471_/Q VGND VGND VPWR VPWR _2320_/A sky130_fd_sc_hd__a22o_1
X_2194_ _4451_/Q VGND VGND VPWR VPWR _2194_/Y sky130_fd_sc_hd__inv_2
XFILLER_80_401 VPWR VGND VPWR VGND sky130_ef_sc_hd__decap_12
XFILLER_53_604 VPWR VGND VPWR VGND sky130_ef_sc_hd__decap_12
XFILLER_65_497 VGND VGND VPWR VPWR sky130_fd_sc_hd__decap_6
XFILLER_80_489 VPWR VGND VPWR VGND sky130_ef_sc_hd__decap_12
XFILLER_40_309 VGND VGND VPWR VPWR sky130_fd_sc_hd__fill_1
X_4766_ _4767_/CLK _4766_/D fanout144/X VGND VGND VPWR VPWR _4766_/Q sky130_fd_sc_hd__dfrtp_1
X_3717_ _3794_/B2 _3715_/Y _3716_/X _3748_/B2 _4541_/Q VGND VGND VPWR VPWR _4541_/D
+ sky130_fd_sc_hd__a32o_1
XTAP_TAPCELL_ROW_31_573 VGND VPWR sky130_fd_sc_hd__tapvpwrvgnd_1
XFILLER_107_617 VPWR VGND VPWR VGND sky130_ef_sc_hd__decap_12
X_4697_ _4699_/CLK _4697_/D fanout159/X VGND VGND VPWR VPWR _4697_/Q sky130_fd_sc_hd__dfrtp_1
XFILLER_20_15 VPWR VGND VPWR VGND sky130_ef_sc_hd__decap_12
X_3648_ _3648_/A _3880_/A VGND VGND VPWR VPWR _3650_/B sky130_fd_sc_hd__xnor2_1
XFILLER_88_501 VPWR VGND VPWR VGND sky130_ef_sc_hd__decap_12
X_3579_ _3606_/B _3580_/B _3578_/Y VGND VGND VPWR VPWR _3581_/B sky130_fd_sc_hd__a21boi_1
XFILLER_0_427 VGND VGND VPWR VPWR sky130_fd_sc_hd__fill_2
XFILLER_102_333 VPWR VGND VPWR VGND sky130_ef_sc_hd__decap_12
XFILLER_88_545 VPWR VGND VPWR VGND sky130_ef_sc_hd__decap_12
XFILLER_0_449 VGND VGND VPWR VPWR sky130_fd_sc_hd__decap_4
Xhold13 hold13/A VGND VGND VPWR VPWR hold13/X sky130_fd_sc_hd__dlygate4sd3_1
XFILLER_102_377 VPWR VGND VPWR VGND sky130_ef_sc_hd__decap_12
XFILLER_88_589 VPWR VGND VPWR VGND sky130_ef_sc_hd__decap_12
Xhold46 hold46/A VGND VGND VPWR VPWR hold46/X sky130_fd_sc_hd__dlygate4sd3_1
Xhold35 hold35/A VGND VGND VPWR VPWR hold35/X sky130_fd_sc_hd__dlygate4sd3_1
XFILLER_29_57 VPWR VGND VPWR VGND sky130_ef_sc_hd__decap_12
Xhold24 hold24/A VGND VGND VPWR VPWR hold24/X sky130_fd_sc_hd__dlygate4sd3_1
Xhold79 hold79/A VGND VGND VPWR VPWR hold79/X sky130_fd_sc_hd__dlygate4sd3_1
Xhold68 hold68/A VGND VGND VPWR VPWR hold68/X sky130_fd_sc_hd__dlygate4sd3_1
Xhold57 hold57/A VGND VGND VPWR VPWR hold57/X sky130_fd_sc_hd__dlygate4sd3_1
XTAP_TAPCELL_ROW_67_971 VGND VPWR sky130_fd_sc_hd__tapvpwrvgnd_1
XTAP_TAPCELL_ROW_3_265 VGND VPWR sky130_fd_sc_hd__tapvpwrvgnd_1
XTAP_TAPCELL_ROW_39_662 VGND VPWR sky130_fd_sc_hd__tapvpwrvgnd_1
XFILLER_101_51 VGND VGND VPWR VPWR sky130_fd_sc_hd__decap_4
XFILLER_12_512 VGND VGND VPWR VPWR sky130_fd_sc_hd__fill_1
XTAP_TAPCELL_ROW_100_1329 VGND VPWR sky130_fd_sc_hd__tapvpwrvgnd_1
XFILLER_61_55 VGND VGND VPWR VPWR sky130_fd_sc_hd__fill_1
XFILLER_98_309 VPWR VGND VPWR VGND sky130_ef_sc_hd__decap_12
XFILLER_105_193 VPWR VGND VPWR VGND sky130_ef_sc_hd__decap_12
XFILLER_86_41 VPWR VGND VPWR VGND sky130_ef_sc_hd__decap_12
XFILLER_86_85 VPWR VGND VPWR VGND sky130_ef_sc_hd__decap_12
XFILLER_66_239 VPWR VGND VPWR VGND sky130_ef_sc_hd__decap_12
XFILLER_62_401 VGND VGND VPWR VPWR sky130_fd_sc_hd__decap_8
XFILLER_74_294 VPWR VGND VPWR VGND sky130_ef_sc_hd__decap_12
XFILLER_62_489 VPWR VGND VPWR VGND sky130_ef_sc_hd__decap_12
XFILLER_22_309 VGND VGND VPWR VPWR sky130_fd_sc_hd__decap_4
X_2950_ _2950_/A _2950_/B VGND VGND VPWR VPWR _2952_/B sky130_fd_sc_hd__xnor2_1
X_2881_ _2869_/B _2873_/B _2869_/A VGND VGND VPWR VPWR _2893_/A sky130_fd_sc_hd__a21bo_1
X_4620_ _4684_/CLK _4620_/D fanout141/X VGND VGND VPWR VPWR hold51/A sky130_fd_sc_hd__dfrtp_1
X_4551_ _4552_/CLK _4551_/D fanout170/X VGND VGND VPWR VPWR _4551_/Q sky130_fd_sc_hd__dfrtp_4
X_4482_ _4734_/CLK _4482_/D fanout148/X VGND VGND VPWR VPWR _4482_/Q sky130_fd_sc_hd__dfrtp_1
X_3502_ _3519_/S _3504_/B VGND VGND VPWR VPWR _3517_/A sky130_fd_sc_hd__or2_1
XTAP_TAPCELL_ROW_77_1077 VGND VPWR sky130_fd_sc_hd__tapvpwrvgnd_1
X_3433_ _3434_/A _3434_/B VGND VGND VPWR VPWR _3433_/Y sky130_fd_sc_hd__nand2b_1
XTAP_TAPCELL_ROW_90_1222 VGND VPWR sky130_fd_sc_hd__tapvpwrvgnd_1
XFILLER_106_29 VPWR VGND VPWR VGND sky130_ef_sc_hd__decap_12
X_3364_ _3353_/B _3353_/C _3353_/A VGND VGND VPWR VPWR _3380_/A sky130_fd_sc_hd__a21boi_1
X_3295_ _3296_/B _4523_/Q VGND VGND VPWR VPWR _3295_/X sky130_fd_sc_hd__and2b_1
X_2315_ _4225_/A _4461_/Q _4701_/Q _2218_/Y _2277_/X VGND VGND VPWR VPWR _2316_/D
+ sky130_fd_sc_hd__o221a_1
XFILLER_85_559 VGND VGND VPWR VPWR sky130_fd_sc_hd__fill_1
X_2246_ _4364_/Q _2245_/B hold133/X VGND VGND VPWR VPWR _4364_/D sky130_fd_sc_hd__a21o_1
XFILLER_26_604 VGND VGND VPWR VPWR sky130_fd_sc_hd__decap_6
XTAP_TAPCELL_ROW_0_224 VGND VPWR sky130_fd_sc_hd__tapvpwrvgnd_1
XTAP_TAPCELL_ROW_0_235 VGND VPWR sky130_fd_sc_hd__tapvpwrvgnd_1
XFILLER_26_626 VGND VGND VPWR VPWR sky130_fd_sc_hd__decap_3
X_2177_ _2431_/A VGND VGND VPWR VPWR _2356_/A sky130_fd_sc_hd__inv_2
XTAP_TAPCELL_ROW_88_1195 VGND VPWR sky130_fd_sc_hd__tapvpwrvgnd_1
XFILLER_65_294 VGND VGND VPWR VPWR sky130_fd_sc_hd__fill_2
XTAP_TAPCELL_ROW_64_941 VGND VPWR sky130_fd_sc_hd__tapvpwrvgnd_1
XTAP_TAPCELL_ROW_36_632 VGND VPWR sky130_fd_sc_hd__tapvpwrvgnd_1
XFILLER_15_15 VPWR VGND VPWR VGND sky130_ef_sc_hd__decap_12
XFILLER_53_478 VGND VGND VPWR VPWR sky130_fd_sc_hd__decap_4
X_4749_ _4749_/CLK _4749_/D fanout128/X VGND VGND VPWR VPWR _4749_/Q sky130_fd_sc_hd__dfrtp_2
XFILLER_31_69 VGND VGND VPWR VPWR sky130_fd_sc_hd__decap_8
XTAP_TAPCELL_ROW_8_324 VGND VPWR sky130_fd_sc_hd__tapvpwrvgnd_1
XFILLER_102_141 VPWR VGND VPWR VGND sky130_ef_sc_hd__decap_12
XFILLER_91_529 VPWR VGND VPWR VGND sky130_ef_sc_hd__decap_12
XFILLER_84_581 VGND VGND VPWR VPWR sky130_fd_sc_hd__decap_6
XFILLER_56_77 VGND VGND VPWR VPWR sky130_fd_sc_hd__decap_6
XFILLER_71_253 VGND VGND VPWR VPWR sky130_fd_sc_hd__decap_3
XFILLER_32_607 VGND VGND VPWR VPWR sky130_fd_sc_hd__fill_2
XFILLER_44_489 VGND VGND VPWR VPWR sky130_fd_sc_hd__decap_8
XFILLER_72_65 VPWR VGND VPWR VGND sky130_ef_sc_hd__decap_12
XFILLER_31_139 VGND VGND VPWR VPWR sky130_fd_sc_hd__decap_8
XTAP_TAPCELL_ROW_70_999 VGND VPWR sky130_fd_sc_hd__tapvpwrvgnd_1
XFILLER_8_335 VGND VGND VPWR VPWR sky130_fd_sc_hd__fill_2
XFILLER_8_324 VGND VGND VPWR VPWR sky130_fd_sc_hd__fill_2
XFILLER_99_629 VGND VGND VPWR VPWR sky130_fd_sc_hd__decap_8
XFILLER_98_139 VGND VGND VPWR VPWR sky130_fd_sc_hd__fill_1
XFILLER_97_51 VGND VGND VPWR VPWR sky130_fd_sc_hd__decap_4
XFILLER_79_375 VGND VGND VPWR VPWR sky130_fd_sc_hd__fill_1
XFILLER_39_206 VGND VGND VPWR VPWR sky130_fd_sc_hd__decap_4
X_3080_ _3880_/A VGND VGND VPWR VPWR _3782_/A sky130_fd_sc_hd__inv_2
XFILLER_67_559 VGND VGND VPWR VPWR sky130_fd_sc_hd__fill_1
XFILLER_54_209 VPWR VGND VPWR VGND sky130_ef_sc_hd__decap_12
XFILLER_94_389 VPWR VGND VPWR VGND sky130_ef_sc_hd__decap_12
X_3982_ _3982_/A _3982_/B VGND VGND VPWR VPWR _3989_/A sky130_fd_sc_hd__xnor2_1
XFILLER_62_264 VGND VGND VPWR VPWR sky130_fd_sc_hd__fill_1
XFILLER_62_253 VGND VGND VPWR VPWR sky130_fd_sc_hd__decap_4
XTAP_TAPCELL_ROW_61_900 VGND VPWR sky130_fd_sc_hd__tapvpwrvgnd_1
XFILLER_22_139 VGND VGND VPWR VPWR sky130_fd_sc_hd__fill_1
X_2933_ _2933_/A _2933_/B VGND VGND VPWR VPWR _3634_/A sky130_fd_sc_hd__xnor2_4
XTAP_TAPCELL_ROW_79_1106 VGND VPWR sky130_fd_sc_hd__tapvpwrvgnd_1
XFILLER_30_150 VPWR VGND VPWR VGND sky130_ef_sc_hd__decap_12
X_2864_ _2841_/A _2841_/B _2840_/B _2838_/Y VGND VGND VPWR VPWR _2865_/B sky130_fd_sc_hd__a31o_1
XTAP_TAPCELL_ROW_13_370 VGND VPWR sky130_fd_sc_hd__tapvpwrvgnd_1
X_2795_ _2795_/A _2795_/B VGND VGND VPWR VPWR _2819_/B sky130_fd_sc_hd__nand2_1
X_4603_ clkload8/A _4603_/D fanout125/X VGND VGND VPWR VPWR _4603_/Q sky130_fd_sc_hd__dfrtp_1
Xhold302 _4459_/Q VGND VGND VPWR VPWR _2491_/A sky130_fd_sc_hd__dlygate4sd3_1
X_4534_ _4536_/CLK _4534_/D fanout154/X VGND VGND VPWR VPWR hold2/A sky130_fd_sc_hd__dfrtp_1
XFILLER_7_93 VGND VGND VPWR VPWR sky130_fd_sc_hd__decap_3
X_4465_ _4708_/CLK _4465_/D fanout164/X VGND VGND VPWR VPWR _4465_/Q sky130_fd_sc_hd__dfrtp_1
X_3416_ _3430_/B _3416_/B VGND VGND VPWR VPWR _3423_/A sky130_fd_sc_hd__nand2_1
X_4396_ _4481_/CLK _4396_/D fanout152/X VGND VGND VPWR VPWR hold63/A sky130_fd_sc_hd__dfrtp_1
XFILLER_100_601 VPWR VGND VPWR VGND sky130_ef_sc_hd__decap_12
XFILLER_97_161 VGND VGND VPWR VPWR sky130_fd_sc_hd__decap_6
X_3347_ _3374_/B _3347_/B VGND VGND VPWR VPWR _3347_/X sky130_fd_sc_hd__and2_1
XFILLER_85_312 VPWR VGND VPWR VGND sky130_ef_sc_hd__decap_12
X_3278_ _3278_/A _3278_/B VGND VGND VPWR VPWR _3279_/B sky130_fd_sc_hd__or2_1
XFILLER_73_529 VPWR VGND VPWR VGND sky130_ef_sc_hd__decap_12
XFILLER_66_581 VGND VGND VPWR VPWR sky130_fd_sc_hd__decap_6
X_2229_ _4653_/Q VGND VGND VPWR VPWR _2229_/Y sky130_fd_sc_hd__inv_2
XFILLER_81_573 VPWR VGND VPWR VGND sky130_ef_sc_hd__decap_12
XFILLER_21_161 VGND VGND VPWR VPWR sky130_fd_sc_hd__decap_6
XFILLER_107_277 VGND VGND VPWR VPWR sky130_fd_sc_hd__decap_3
XFILLER_101_3 VPWR VGND VPWR VGND sky130_ef_sc_hd__decap_12
XFILLER_103_461 VPWR VGND VPWR VGND sky130_ef_sc_hd__decap_12
XFILLER_76_334 VGND VGND VPWR VPWR sky130_fd_sc_hd__decap_6
XFILLER_91_315 VGND VGND VPWR VPWR sky130_fd_sc_hd__decap_6
XFILLER_91_337 VGND VGND VPWR VPWR sky130_fd_sc_hd__fill_2
XFILLER_44_220 VPWR VGND VPWR VGND sky130_ef_sc_hd__decap_12
XTAP_TAPCELL_ROW_47_749 VGND VPWR sky130_fd_sc_hd__tapvpwrvgnd_1
XFILLER_44_297 VGND VGND VPWR VPWR sky130_fd_sc_hd__fill_2
XFILLER_40_492 VGND VGND VPWR VPWR sky130_fd_sc_hd__fill_1
XTAP_TAPCELL_ROW_10_340 VGND VPWR sky130_fd_sc_hd__tapvpwrvgnd_1
X_2580_ _2222_/Y _2223_/Y _4622_/Q _4654_/Q _3278_/A _3278_/B VGND VGND VPWR VPWR
+ _2581_/B sky130_fd_sc_hd__mux4_1
XTAP_TAPCELL_ROW_74_1047 VGND VPWR sky130_fd_sc_hd__tapvpwrvgnd_1
X_4250_ _4250_/A _4250_/B VGND VGND VPWR VPWR _4253_/B sky130_fd_sc_hd__nor2_1
X_3201_ _3201_/A _3201_/B VGND VGND VPWR VPWR _3203_/A sky130_fd_sc_hd__nor2_1
X_4181_ _4692_/Q _4183_/C VGND VGND VPWR VPWR _4181_/X sky130_fd_sc_hd__or2_1
X_3132_ _4761_/Q _3133_/B VGND VGND VPWR VPWR _3159_/A sky130_fd_sc_hd__nand2_1
XFILLER_94_153 VPWR VGND VPWR VGND sky130_ef_sc_hd__decap_12
XFILLER_67_378 VGND VGND VPWR VPWR sky130_fd_sc_hd__decap_3
X_3063_ _3012_/B _3061_/Y _3062_/Y VGND VGND VPWR VPWR _3064_/B sky130_fd_sc_hd__a21o_1
XFILLER_94_197 VPWR VGND VPWR VGND sky130_ef_sc_hd__decap_12
XTAP_TAPCELL_ROW_85_1165 VGND VPWR sky130_fd_sc_hd__tapvpwrvgnd_1
XFILLER_63_573 VPWR VGND VPWR VGND sky130_ef_sc_hd__decap_12
X_3965_ _3965_/A _3965_/B VGND VGND VPWR VPWR _3971_/A sky130_fd_sc_hd__nor2_1
X_3896_ _3897_/A _3897_/B VGND VGND VPWR VPWR _3918_/A sky130_fd_sc_hd__nand2b_1
X_2916_ _2916_/A _2916_/B VGND VGND VPWR VPWR _2919_/C sky130_fd_sc_hd__or2_1
XFILLER_50_278 VGND VGND VPWR VPWR sky130_fd_sc_hd__fill_2
XFILLER_12_27 VGND VGND VPWR VPWR sky130_fd_sc_hd__fill_1
X_2847_ _2871_/A _2847_/B VGND VGND VPWR VPWR _2919_/B sky130_fd_sc_hd__or2_1
Xhold110 _4652_/Q VGND VGND VPWR VPWR hold110/X sky130_fd_sc_hd__dlygate4sd3_1
X_2778_ _2778_/A _2778_/B VGND VGND VPWR VPWR _2831_/B sky130_fd_sc_hd__or2_1
XTAP_TAPCELL_ROW_96_1283 VGND VPWR sky130_fd_sc_hd__tapvpwrvgnd_1
X_4517_ _4517_/CLK _4517_/D fanout144/X VGND VGND VPWR VPWR _4517_/Q sky130_fd_sc_hd__dfrtp_2
Xhold132 _4641_/Q VGND VGND VPWR VPWR hold132/X sky130_fd_sc_hd__dlygate4sd3_1
Xhold143 _4485_/Q VGND VGND VPWR VPWR hold143/X sky130_fd_sc_hd__dlygate4sd3_1
Xhold121 _4640_/Q VGND VGND VPWR VPWR hold121/X sky130_fd_sc_hd__dlygate4sd3_1
X_4448_ _4721_/CLK _4448_/D fanout157/X VGND VGND VPWR VPWR _4448_/Q sky130_fd_sc_hd__dfrtp_1
Xhold154 _4554_/Q VGND VGND VPWR VPWR hold154/X sky130_fd_sc_hd__dlygate4sd3_1
Xhold165 _4658_/Q VGND VGND VPWR VPWR hold165/X sky130_fd_sc_hd__dlygate4sd3_1
Xhold176 _4433_/Q VGND VGND VPWR VPWR hold176/X sky130_fd_sc_hd__dlygate4sd3_1
Xhold187 _4482_/Q VGND VGND VPWR VPWR hold187/X sky130_fd_sc_hd__dlygate4sd3_1
Xhold198 _4716_/Q VGND VGND VPWR VPWR hold198/X sky130_fd_sc_hd__dlygate4sd3_1
X_4379_ _4726_/CLK _4379_/D fanout153/X VGND VGND VPWR VPWR _4379_/Q sky130_fd_sc_hd__dfrtp_1
XFILLER_100_475 VGND VGND VPWR VPWR sky130_fd_sc_hd__fill_1
XFILLER_37_57 VPWR VGND VPWR VGND sky130_ef_sc_hd__decap_12
XFILLER_73_337 VGND VGND VPWR VPWR sky130_fd_sc_hd__fill_2
XFILLER_26_231 VGND VGND VPWR VPWR sky130_fd_sc_hd__fill_1
XFILLER_26_253 VPWR VGND VPWR VGND sky130_ef_sc_hd__decap_12
XTAP_TAPCELL_ROW_44_719 VGND VPWR sky130_fd_sc_hd__tapvpwrvgnd_1
XFILLER_14_437 VPWR VGND VPWR VGND sky130_ef_sc_hd__decap_12
XFILLER_41_223 VGND VGND VPWR VPWR sky130_fd_sc_hd__fill_1
XTAP_TAPCELL_ROW_105_1390 VGND VPWR sky130_fd_sc_hd__tapvpwrvgnd_1
XTAP_TAPCELL_ROW_24_498 VGND VPWR sky130_fd_sc_hd__tapvpwrvgnd_1
XFILLER_6_625 VPWR VGND VPWR VGND sky130_ef_sc_hd__decap_12
XFILLER_5_113 VGND VGND VPWR VPWR sky130_fd_sc_hd__fill_1
XFILLER_78_53 VPWR VGND VPWR VGND sky130_ef_sc_hd__decap_12
XFILLER_1_352 VGND VGND VPWR VPWR sky130_fd_sc_hd__decap_4
XFILLER_76_131 VGND VGND VPWR VPWR sky130_fd_sc_hd__fill_1
XFILLER_49_345 VGND VGND VPWR VPWR sky130_fd_sc_hd__fill_2
XFILLER_94_41 VPWR VGND VPWR VGND sky130_ef_sc_hd__decap_12
XFILLER_92_613 VPWR VGND VPWR VGND sky130_ef_sc_hd__decap_12
XFILLER_37_529 VGND VGND VPWR VPWR sky130_fd_sc_hd__fill_2
XFILLER_94_85 VPWR VGND VPWR VGND sky130_ef_sc_hd__decap_12
X_3750_ _3776_/A _3776_/B VGND VGND VPWR VPWR _3762_/A sky130_fd_sc_hd__nand2_1
XFILLER_60_587 VGND VGND VPWR VPWR sky130_fd_sc_hd__fill_1
XFILLER_20_418 VGND VGND VPWR VPWR sky130_fd_sc_hd__fill_2
X_2701_ _2710_/B _2701_/B VGND VGND VPWR VPWR _2702_/B sky130_fd_sc_hd__xnor2_1
X_3681_ _3634_/A _3634_/B _3650_/B _3650_/A VGND VGND VPWR VPWR _3681_/X sky130_fd_sc_hd__o22a_1
XFILLER_64_3 VPWR VGND VPWR VGND sky130_ef_sc_hd__decap_12
X_2632_ _2711_/A _2633_/B VGND VGND VPWR VPWR _2648_/B sky130_fd_sc_hd__nor2_1
X_2563_ hold175/X _4732_/Q _2566_/S VGND VGND VPWR VPWR _4486_/D sky130_fd_sc_hd__mux2_1
XFILLER_99_223 VGND VGND VPWR VPWR sky130_fd_sc_hd__fill_1
X_4302_ uo_out[4] _4301_/Y _4323_/S VGND VGND VPWR VPWR _4723_/D sky130_fd_sc_hd__mux2_1
X_2494_ _2495_/A _2495_/B VGND VGND VPWR VPWR _2494_/Y sky130_fd_sc_hd__nand2_1
X_4233_ _4707_/Q _4235_/C VGND VGND VPWR VPWR _4233_/Y sky130_fd_sc_hd__nand2_1
XFILLER_101_217 VGND VGND VPWR VPWR sky130_fd_sc_hd__decap_6
XFILLER_4_83 VGND VGND VPWR VPWR sky130_fd_sc_hd__fill_1
X_4164_ _4685_/Q _4686_/Q _4687_/Q VGND VGND VPWR VPWR _4164_/X sky130_fd_sc_hd__a21o_1
XFILLER_95_473 VPWR VGND VPWR VGND sky130_ef_sc_hd__decap_12
X_3115_ _3115_/A _3115_/B VGND VGND VPWR VPWR _3124_/A sky130_fd_sc_hd__xnor2_1
X_4095_ _4095_/A _4095_/B VGND VGND VPWR VPWR _4095_/Y sky130_fd_sc_hd__nor2_2
X_3046_ _3046_/A _3046_/B VGND VGND VPWR VPWR _3047_/A sky130_fd_sc_hd__or2_1
XFILLER_51_521 VGND VGND VPWR VPWR sky130_fd_sc_hd__fill_2
XFILLER_51_554 VGND VGND VPWR VPWR sky130_fd_sc_hd__decap_6
XFILLER_23_15 VPWR VGND VPWR VGND sky130_ef_sc_hd__decap_12
XTAP_TAPCELL_ROW_98_1312 VGND VPWR sky130_fd_sc_hd__tapvpwrvgnd_1
X_3948_ _3946_/Y _3948_/B VGND VGND VPWR VPWR _3950_/A sky130_fd_sc_hd__and2b_1
X_3879_ _3898_/B _3879_/B VGND VGND VPWR VPWR _3885_/A sky130_fd_sc_hd__and2_1
XTAP_TAPCELL_ROW_21_468 VGND VPWR sky130_fd_sc_hd__tapvpwrvgnd_1
XFILLER_3_617 VPWR VGND VPWR VGND sky130_ef_sc_hd__decap_12
XFILLER_2_149 VGND VGND VPWR VPWR sky130_fd_sc_hd__fill_1
XFILLER_74_613 VPWR VGND VPWR VGND sky130_ef_sc_hd__decap_12
XFILLER_48_89 VGND VGND VPWR VPWR sky130_fd_sc_hd__decap_3
XFILLER_0_19 VGND VGND VPWR VPWR sky130_fd_sc_hd__decap_4
XTAP_TAPCELL_ROW_29_546 VGND VPWR sky130_fd_sc_hd__tapvpwrvgnd_1
XTAP_TAPCELL_ROW_57_855 VGND VPWR sky130_fd_sc_hd__tapvpwrvgnd_1
XFILLER_58_197 VPWR VGND VPWR VGND sky130_ef_sc_hd__decap_12
XFILLER_73_167 VGND VGND VPWR VPWR sky130_fd_sc_hd__fill_1
XFILLER_61_307 VGND VGND VPWR VPWR sky130_fd_sc_hd__fill_2
XFILLER_46_359 VGND VGND VPWR VPWR sky130_fd_sc_hd__decap_4
XFILLER_64_77 VGND VGND VPWR VPWR sky130_fd_sc_hd__decap_6
XFILLER_14_223 VGND VGND VPWR VPWR sky130_fd_sc_hd__fill_1
XFILLER_42_554 VGND VGND VPWR VPWR sky130_fd_sc_hd__fill_1
XFILLER_9_39 VPWR VGND VPWR VGND sky130_ef_sc_hd__decap_12
XFILLER_42_587 VGND VGND VPWR VPWR sky130_fd_sc_hd__fill_1
XFILLER_80_65 VPWR VGND VPWR VGND sky130_ef_sc_hd__decap_12
Xfanout71 _2983_/B2 VGND VGND VPWR VPWR _2708_/B2 sky130_fd_sc_hd__clkbuf_2
Xfanout60 _4238_/B1 VGND VGND VPWR VPWR _4206_/B1 sky130_fd_sc_hd__buf_2
Xfanout82 fanout86/X VGND VGND VPWR VPWR _4339_/A2 sky130_fd_sc_hd__clkbuf_4
XFILLER_6_400 VPWR VGND VPWR VGND sky130_ef_sc_hd__decap_12
Xfanout93 _2431_/Y VGND VGND VPWR VPWR _3813_/A2 sky130_fd_sc_hd__clkbuf_2
XFILLER_13_81 VPWR VGND VPWR VGND sky130_ef_sc_hd__decap_12
XTAP_TAPCELL_ROW_71_1017 VGND VPWR sky130_fd_sc_hd__tapvpwrvgnd_1
XFILLER_69_407 VGND VGND VPWR VPWR sky130_fd_sc_hd__decap_4
XFILLER_77_473 VPWR VGND VPWR VGND sky130_ef_sc_hd__decap_12
XFILLER_49_164 VGND VGND VPWR VPWR sky130_fd_sc_hd__decap_4
XFILLER_92_421 VPWR VGND VPWR VGND sky130_ef_sc_hd__decap_12
XFILLER_37_337 VGND VGND VPWR VPWR sky130_fd_sc_hd__decap_6
XFILLER_64_145 VGND VGND VPWR VPWR sky130_fd_sc_hd__fill_1
XFILLER_18_573 VGND VGND VPWR VPWR sky130_fd_sc_hd__fill_1
XTAP_TAPCELL_ROW_82_1135 VGND VPWR sky130_fd_sc_hd__tapvpwrvgnd_1
X_3802_ _3849_/B _3802_/B VGND VGND VPWR VPWR _3805_/A sky130_fd_sc_hd__nor2_1
XFILLER_60_373 VPWR VGND VPWR VGND sky130_ef_sc_hd__decap_12
XFILLER_20_237 VGND VGND VPWR VPWR sky130_fd_sc_hd__decap_3
X_3733_ _3733_/A _3733_/B VGND VGND VPWR VPWR _3733_/X sky130_fd_sc_hd__or2_1
X_3664_ _3664_/A _3664_/B _3689_/B VGND VGND VPWR VPWR _3664_/X sky130_fd_sc_hd__or3_1
XFILLER_106_309 VPWR VGND VPWR VGND sky130_ef_sc_hd__decap_12
X_2615_ _4739_/Q _2615_/B VGND VGND VPWR VPWR _2616_/B sky130_fd_sc_hd__and2_1
Xclkload30 _4735_/CLK VGND VGND VPWR VPWR clkload30/X sky130_fd_sc_hd__clkbuf_4
Xclkload41 _4724_/CLK VGND VGND VPWR VPWR clkload41/Y sky130_fd_sc_hd__clkinv_2
Xclkload52 _4716_/CLK VGND VGND VPWR VPWR clkload52/Y sky130_fd_sc_hd__inv_6
X_3595_ _3696_/A _3595_/B VGND VGND VPWR VPWR _3628_/C sky130_fd_sc_hd__xor2_1
XTAP_TAPCELL_ROW_93_1253 VGND VPWR sky130_fd_sc_hd__tapvpwrvgnd_1
XFILLER_0_609 VGND VGND VPWR VPWR sky130_fd_sc_hd__fill_2
X_2546_ _2432_/A _2544_/Y _2545_/X _3748_/B2 hold89/X VGND VGND VPWR VPWR _4476_/D
+ sky130_fd_sc_hd__a32o_1
X_2477_ _2478_/A _2478_/B VGND VGND VPWR VPWR _2477_/Y sky130_fd_sc_hd__nand2_1
XFILLER_87_237 VPWR VGND VPWR VGND sky130_ef_sc_hd__decap_12
X_4216_ _4218_/B VGND VGND VPWR VPWR _4216_/Y sky130_fd_sc_hd__inv_2
XFILLER_68_473 VGND VGND VPWR VPWR sky130_fd_sc_hd__decap_3
X_4147_ hold129/X _4028_/X _4148_/S VGND VGND VPWR VPWR _4675_/D sky130_fd_sc_hd__mux2_1
XFILLER_18_15 VPWR VGND VPWR VGND sky130_ef_sc_hd__decap_12
XFILLER_56_613 VPWR VGND VPWR VGND sky130_ef_sc_hd__decap_12
XFILLER_95_281 VPWR VGND VPWR VGND sky130_ef_sc_hd__decap_12
X_4078_ _4149_/B _4013_/Y _4133_/A1 _2352_/A hold46/X VGND VGND VPWR VPWR _4614_/D
+ sky130_fd_sc_hd__a32o_1
XFILLER_28_359 VGND VGND VPWR VPWR sky130_fd_sc_hd__decap_4
XFILLER_55_167 VGND VGND VPWR VPWR sky130_fd_sc_hd__fill_1
XTAP_TAPCELL_ROW_26_516 VGND VPWR sky130_fd_sc_hd__tapvpwrvgnd_1
X_3029_ _2878_/C _2930_/X _2931_/X _3028_/X VGND VGND VPWR VPWR _3033_/B sky130_fd_sc_hd__a211o_1
XTAP_TAPCELL_ROW_54_825 VGND VPWR sky130_fd_sc_hd__tapvpwrvgnd_1
XFILLER_11_204 VGND VGND VPWR VPWR sky130_fd_sc_hd__decap_4
XFILLER_24_576 VGND VGND VPWR VPWR sky130_fd_sc_hd__fill_1
Xclkload2 clkload2/A VGND VGND VPWR VPWR clkload2/X sky130_fd_sc_hd__clkbuf_4
XFILLER_59_55 VGND VGND VPWR VPWR sky130_fd_sc_hd__fill_1
XFILLER_74_421 VGND VGND VPWR VPWR sky130_fd_sc_hd__fill_2
XTAP_TAPCELL_ROW_6_296 VGND VPWR sky130_fd_sc_hd__tapvpwrvgnd_1
XFILLER_75_87 VGND VGND VPWR VPWR sky130_fd_sc_hd__fill_1
XFILLER_34_318 VGND VGND VPWR VPWR sky130_fd_sc_hd__decap_6
XFILLER_6_230 VGND VGND VPWR VPWR sky130_fd_sc_hd__decap_6
X_2400_ hold21/X _2408_/A2 _2408_/B1 _4501_/Q VGND VGND VPWR VPWR _4415_/D sky130_fd_sc_hd__a22o_1
X_3380_ _3380_/A _3380_/B _3380_/C VGND VGND VPWR VPWR _3382_/B sky130_fd_sc_hd__and3_1
X_2331_ input4/X _4718_/D VGND VGND VPWR VPWR _4730_/D sky130_fd_sc_hd__and2_1
X_2262_ _4265_/A _4472_/Q VGND VGND VPWR VPWR _2262_/Y sky130_fd_sc_hd__nor2_1
X_4001_ hold254/X _4729_/Q _4007_/S VGND VGND VPWR VPWR _4558_/D sky130_fd_sc_hd__mux2_1
XFILLER_27_3 VPWR VGND VPWR VGND sky130_ef_sc_hd__decap_12
XFILLER_77_281 VGND VGND VPWR VPWR sky130_fd_sc_hd__fill_1
XFILLER_77_270 VGND VGND VPWR VPWR sky130_fd_sc_hd__decap_8
XFILLER_65_410 VPWR VGND VPWR VGND sky130_ef_sc_hd__decap_12
X_2193_ _4452_/Q VGND VGND VPWR VPWR _2193_/Y sky130_fd_sc_hd__inv_2
XFILLER_38_624 VGND VGND VPWR VPWR sky130_fd_sc_hd__decap_4
XFILLER_1_51 VGND VGND VPWR VPWR sky130_fd_sc_hd__decap_4
XFILLER_80_424 VGND VGND VPWR VPWR sky130_fd_sc_hd__decap_3
XFILLER_60_192 VGND VGND VPWR VPWR sky130_fd_sc_hd__decap_4
X_4765_ _4767_/CLK _4765_/D fanout144/X VGND VGND VPWR VPWR _4765_/Q sky130_fd_sc_hd__dfrtp_2
X_3716_ _3716_/A _3718_/C _3716_/C VGND VGND VPWR VPWR _3716_/X sky130_fd_sc_hd__or3_1
XTAP_TAPCELL_ROW_31_574 VGND VPWR sky130_fd_sc_hd__tapvpwrvgnd_1
XFILLER_107_629 VGND VGND VPWR VPWR sky130_fd_sc_hd__decap_8
X_4696_ _4699_/CLK _4696_/D fanout158/X VGND VGND VPWR VPWR _4696_/Q sky130_fd_sc_hd__dfrtp_1
XFILLER_106_139 VGND VGND VPWR VPWR sky130_fd_sc_hd__fill_1
XFILLER_20_27 VGND VGND VPWR VPWR sky130_fd_sc_hd__fill_1
X_3647_ _3634_/A _3634_/B _3636_/X VGND VGND VPWR VPWR _3661_/A sky130_fd_sc_hd__o21a_1
X_3578_ _3578_/A _3578_/B VGND VGND VPWR VPWR _3578_/Y sky130_fd_sc_hd__xnor2_1
XFILLER_102_301 VGND VGND VPWR VPWR sky130_fd_sc_hd__decap_6
XFILLER_88_513 VPWR VGND VPWR VGND sky130_ef_sc_hd__decap_12
X_2529_ _2529_/A _2529_/B VGND VGND VPWR VPWR _2529_/Y sky130_fd_sc_hd__nand2_1
XFILLER_102_345 VPWR VGND VPWR VGND sky130_ef_sc_hd__decap_12
XFILLER_88_557 VPWR VGND VPWR VGND sky130_ef_sc_hd__decap_12
Xhold14 hold14/A VGND VGND VPWR VPWR hold14/X sky130_fd_sc_hd__dlygate4sd3_1
Xhold36 hold36/A VGND VGND VPWR VPWR hold36/X sky130_fd_sc_hd__dlygate4sd3_1
XFILLER_29_69 VGND VGND VPWR VPWR sky130_fd_sc_hd__decap_8
Xhold25 hold25/A VGND VGND VPWR VPWR hold25/X sky130_fd_sc_hd__dlygate4sd3_1
Xhold47 hold47/A VGND VGND VPWR VPWR hold47/X sky130_fd_sc_hd__dlygate4sd3_1
XFILLER_102_389 VPWR VGND VPWR VGND sky130_ef_sc_hd__decap_12
Xhold58 hold58/A VGND VGND VPWR VPWR hold58/X sky130_fd_sc_hd__dlygate4sd3_1
Xhold69 hold69/A VGND VGND VPWR VPWR hold69/X sky130_fd_sc_hd__dlygate4sd3_1
XFILLER_56_421 VGND VGND VPWR VPWR sky130_fd_sc_hd__decap_8
XTAP_TAPCELL_ROW_3_266 VGND VPWR sky130_fd_sc_hd__tapvpwrvgnd_1
XTAP_TAPCELL_ROW_67_972 VGND VPWR sky130_fd_sc_hd__tapvpwrvgnd_1
XFILLER_16_318 VPWR VGND VPWR VGND sky130_ef_sc_hd__decap_12
XTAP_TAPCELL_ROW_39_663 VGND VPWR sky130_fd_sc_hd__tapvpwrvgnd_1
XFILLER_43_159 VGND VGND VPWR VPWR sky130_fd_sc_hd__decap_8
XFILLER_45_57 VGND VGND VPWR VPWR sky130_fd_sc_hd__decap_8
XFILLER_12_502 VGND VGND VPWR VPWR sky130_fd_sc_hd__fill_2
XFILLER_51_192 VGND VGND VPWR VPWR sky130_fd_sc_hd__fill_1
XFILLER_6_29 VPWR VGND VPWR VGND sky130_ef_sc_hd__decap_12
XFILLER_105_161 VGND VGND VPWR VPWR sky130_fd_sc_hd__decap_6
XFILLER_86_53 VPWR VGND VPWR VGND sky130_ef_sc_hd__decap_12
XFILLER_86_97 VGND VGND VPWR VPWR sky130_fd_sc_hd__decap_4
XFILLER_19_134 VGND VGND VPWR VPWR sky130_fd_sc_hd__decap_4
XFILLER_74_251 VGND VGND VPWR VPWR sky130_fd_sc_hd__fill_1
XFILLER_19_178 VGND VGND VPWR VPWR sky130_fd_sc_hd__decap_8
XFILLER_50_619 VPWR VGND VPWR VGND sky130_ef_sc_hd__decap_12
X_2880_ hold275/X _2983_/A2 _3676_/A _2983_/B2 VGND VGND VPWR VPWR _4504_/D sky130_fd_sc_hd__a22o_1
XFILLER_30_387 VGND VGND VPWR VPWR sky130_fd_sc_hd__decap_4
X_4550_ _4552_/CLK _4550_/D fanout170/X VGND VGND VPWR VPWR _4550_/Q sky130_fd_sc_hd__dfrtp_4
XFILLER_7_594 VGND VGND VPWR VPWR sky130_fd_sc_hd__decap_8
XFILLER_7_561 VGND VGND VPWR VPWR sky130_fd_sc_hd__decap_4
X_3501_ hold64/A hold69/A _4664_/Q _4600_/Q _3599_/S0 _3519_/S VGND VGND VPWR VPWR
+ _3504_/B sky130_fd_sc_hd__mux4_1
X_4481_ _4481_/CLK _4481_/D fanout162/X VGND VGND VPWR VPWR _4481_/Q sky130_fd_sc_hd__dfrtp_1
XTAP_TAPCELL_ROW_77_1078 VGND VPWR sky130_fd_sc_hd__tapvpwrvgnd_1
X_3432_ _4629_/Q _4565_/Q _4661_/Q _4597_/Q _3599_/S0 _3519_/S VGND VGND VPWR VPWR
+ _3434_/B sky130_fd_sc_hd__mux4_2
XTAP_TAPCELL_ROW_90_1223 VGND VPWR sky130_fd_sc_hd__tapvpwrvgnd_1
X_3363_ _3358_/X _3359_/X _3357_/Y VGND VGND VPWR VPWR _3363_/X sky130_fd_sc_hd__a21bo_1
XFILLER_85_505 VPWR VGND VPWR VGND sky130_ef_sc_hd__decap_12
X_3294_ _3294_/A _3294_/B VGND VGND VPWR VPWR _3296_/B sky130_fd_sc_hd__xor2_1
X_2314_ _4215_/A _4458_/Q _2217_/Y _4457_/Q _2279_/X VGND VGND VPWR VPWR _2316_/C
+ sky130_fd_sc_hd__o221a_1
X_2245_ _2431_/A _2245_/B VGND VGND VPWR VPWR _2245_/Y sky130_fd_sc_hd__nor2_1
XFILLER_38_421 VGND VGND VPWR VPWR sky130_fd_sc_hd__decap_8
X_2176_ _4440_/Q VGND VGND VPWR VPWR _2176_/Y sky130_fd_sc_hd__inv_2
XFILLER_65_262 VPWR VGND VPWR VGND sky130_ef_sc_hd__decap_12
XFILLER_65_251 VGND VGND VPWR VPWR sky130_fd_sc_hd__decap_6
XTAP_TAPCELL_ROW_0_225 VGND VPWR sky130_fd_sc_hd__tapvpwrvgnd_1
XTAP_TAPCELL_ROW_0_236 VGND VPWR sky130_fd_sc_hd__tapvpwrvgnd_1
XTAP_TAPCELL_ROW_88_1196 VGND VPWR sky130_fd_sc_hd__tapvpwrvgnd_1
XFILLER_80_232 VGND VGND VPWR VPWR sky130_fd_sc_hd__decap_4
XTAP_TAPCELL_ROW_64_931 VGND VPWR sky130_fd_sc_hd__tapvpwrvgnd_1
XTAP_TAPCELL_ROW_36_633 VGND VPWR sky130_fd_sc_hd__tapvpwrvgnd_1
XFILLER_80_265 VGND VGND VPWR VPWR sky130_fd_sc_hd__fill_2
XFILLER_15_27 VPWR VGND VPWR VGND sky130_ef_sc_hd__decap_12
XFILLER_33_192 VGND VGND VPWR VPWR sky130_fd_sc_hd__decap_3
XFILLER_31_15 VPWR VGND VPWR VGND sky130_ef_sc_hd__decap_12
X_4748_ _4749_/CLK _4748_/D fanout127/X VGND VGND VPWR VPWR _4748_/Q sky130_fd_sc_hd__dfrtp_1
X_4679_ _4679_/CLK _4679_/D fanout139/X VGND VGND VPWR VPWR hold70/A sky130_fd_sc_hd__dfrtp_1
XPHY_EDGE_ROW_1_Right_1 VGND VGND VPWR VPWR sky130_fd_sc_hd__decap_3
XTAP_TAPCELL_ROW_8_325 VGND VPWR sky130_fd_sc_hd__tapvpwrvgnd_1
XFILLER_0_225 VPWR VGND VPWR VGND sky130_ef_sc_hd__decap_12
XFILLER_102_153 VPWR VGND VPWR VGND sky130_ef_sc_hd__decap_12
XFILLER_88_365 VGND VGND VPWR VPWR sky130_fd_sc_hd__fill_2
XFILLER_48_207 VGND VGND VPWR VPWR sky130_fd_sc_hd__fill_2
XFILLER_102_197 VPWR VGND VPWR VGND sky130_ef_sc_hd__decap_12
XFILLER_16_104 VGND VGND VPWR VPWR sky130_fd_sc_hd__decap_3
XFILLER_71_232 VGND VGND VPWR VPWR sky130_fd_sc_hd__fill_1
XFILLER_71_210 VPWR VGND VPWR VGND sky130_ef_sc_hd__decap_12
XFILLER_72_77 VGND VGND VPWR VPWR sky130_fd_sc_hd__decap_6
XFILLER_12_332 VPWR VGND VPWR VGND sky130_ef_sc_hd__decap_12
Xclkbuf_leaf_51_clk clkload4/A VGND VGND VPWR VPWR _4495_/CLK sky130_fd_sc_hd__clkbuf_8
XFILLER_21_81 VPWR VGND VPWR VGND sky130_ef_sc_hd__decap_12
XFILLER_4_575 VGND VGND VPWR VPWR sky130_fd_sc_hd__decap_4
XFILLER_67_505 VPWR VGND VPWR VGND sky130_ef_sc_hd__decap_12
XFILLER_35_413 VPWR VGND VPWR VGND sky130_ef_sc_hd__decap_12
XFILLER_35_435 VPWR VGND VPWR VGND sky130_ef_sc_hd__decap_12
XFILLER_47_295 VPWR VGND VPWR VGND sky130_ef_sc_hd__decap_12
X_3981_ _3962_/A _3962_/B _3965_/A VGND VGND VPWR VPWR _3982_/B sky130_fd_sc_hd__a21o_1
XTAP_TAPCELL_ROW_61_901 VGND VPWR sky130_fd_sc_hd__tapvpwrvgnd_1
XFILLER_62_298 VGND VGND VPWR VPWR sky130_fd_sc_hd__decap_3
X_2932_ _2878_/C _2930_/X _2931_/X VGND VGND VPWR VPWR _2933_/B sky130_fd_sc_hd__a21oi_4
XFILLER_94_3 VPWR VGND VPWR VGND sky130_ef_sc_hd__decap_12
Xclkbuf_leaf_42_clk _4459_/CLK VGND VGND VPWR VPWR _4727_/CLK sky130_fd_sc_hd__clkbuf_8
XFILLER_43_490 VGND VGND VPWR VPWR sky130_fd_sc_hd__fill_1
XFILLER_30_162 VGND VGND VPWR VPWR sky130_fd_sc_hd__decap_4
X_2863_ _2841_/A _2838_/Y _2840_/B VGND VGND VPWR VPWR _2863_/X sky130_fd_sc_hd__o21a_1
XTAP_TAPCELL_ROW_13_371 VGND VPWR sky130_fd_sc_hd__tapvpwrvgnd_1
X_2794_ _4533_/Q _2794_/B VGND VGND VPWR VPWR _2795_/B sky130_fd_sc_hd__or2_1
X_4602_ _4667_/CLK _4602_/D fanout125/X VGND VGND VPWR VPWR _4602_/Q sky130_fd_sc_hd__dfrtp_1
XTAP_TAPCELL_ROW_41_680 VGND VPWR sky130_fd_sc_hd__tapvpwrvgnd_1
X_4533_ _4533_/CLK _4533_/D fanout154/X VGND VGND VPWR VPWR _4533_/Q sky130_fd_sc_hd__dfrtp_4
Xhold303 _4516_/Q VGND VGND VPWR VPWR hold303/X sky130_fd_sc_hd__dlygate4sd3_1
XFILLER_7_380 VGND VGND VPWR VPWR sky130_fd_sc_hd__decap_3
X_4464_ _4708_/CLK _4464_/D fanout164/X VGND VGND VPWR VPWR hold60/A sky130_fd_sc_hd__dfrtp_1
X_3415_ _3415_/A _3415_/B _3415_/C VGND VGND VPWR VPWR _3416_/B sky130_fd_sc_hd__nand3_1
X_4395_ _4538_/CLK _4395_/D fanout167/X VGND VGND VPWR VPWR hold82/A sky130_fd_sc_hd__dfrtp_1
X_3346_ _3346_/A _3346_/B _3346_/C VGND VGND VPWR VPWR _3347_/B sky130_fd_sc_hd__nand3_1
XFILLER_100_613 VPWR VGND VPWR VGND sky130_ef_sc_hd__decap_12
XFILLER_85_324 VPWR VGND VPWR VGND sky130_ef_sc_hd__decap_12
X_3277_ _3298_/A _3276_/Y _4522_/Q _3277_/B2 VGND VGND VPWR VPWR _4522_/D sky130_fd_sc_hd__a2bb2o_1
X_2228_ _4621_/Q VGND VGND VPWR VPWR _2228_/Y sky130_fd_sc_hd__inv_2
XFILLER_26_15 VPWR VGND VPWR VGND sky130_ef_sc_hd__decap_12
XFILLER_81_541 VPWR VGND VPWR VGND sky130_ef_sc_hd__decap_12
XFILLER_81_585 VPWR VGND VPWR VGND sky130_ef_sc_hd__decap_12
XFILLER_41_449 VGND VGND VPWR VPWR sky130_fd_sc_hd__fill_2
Xclkbuf_leaf_33_clk _4459_/CLK VGND VGND VPWR VPWR _4770_/CLK sky130_fd_sc_hd__clkbuf_8
XFILLER_107_223 VGND VGND VPWR VPWR sky130_fd_sc_hd__fill_1
XFILLER_103_473 VPWR VGND VPWR VGND sky130_ef_sc_hd__decap_12
XFILLER_76_302 VGND VGND VPWR VPWR sky130_fd_sc_hd__fill_1
XFILLER_67_55 VGND VGND VPWR VPWR sky130_fd_sc_hd__fill_1
XFILLER_17_402 VGND VGND VPWR VPWR sky130_fd_sc_hd__decap_6
XFILLER_17_413 VGND VGND VPWR VPWR sky130_fd_sc_hd__decap_8
XFILLER_29_251 VPWR VGND VPWR VGND sky130_ef_sc_hd__decap_12
XFILLER_17_435 VPWR VGND VPWR VGND sky130_ef_sc_hd__decap_12
XPHY_EDGE_ROW_17_Left_125 VGND VGND VPWR VPWR sky130_fd_sc_hd__decap_3
Xclkbuf_leaf_24_clk clkload3/A VGND VGND VPWR VPWR _4519_/CLK sky130_fd_sc_hd__clkbuf_8
XFILLER_12_195 VGND VGND VPWR VPWR sky130_fd_sc_hd__fill_1
XTAP_TAPCELL_ROW_10_341 VGND VPWR sky130_fd_sc_hd__tapvpwrvgnd_1
XFILLER_99_405 VPWR VGND VPWR VGND sky130_ef_sc_hd__decap_12
XFILLER_99_449 VPWR VGND VPWR VGND sky130_ef_sc_hd__decap_12
XTAP_TAPCELL_ROW_74_1048 VGND VPWR sky130_fd_sc_hd__tapvpwrvgnd_1
XPHY_EDGE_ROW_26_Left_134 VGND VGND VPWR VPWR sky130_fd_sc_hd__decap_3
X_3200_ _3836_/A _4550_/Q VGND VGND VPWR VPWR _3201_/B sky130_fd_sc_hd__nor2_1
X_4180_ _4692_/Q _4183_/C VGND VGND VPWR VPWR _4180_/Y sky130_fd_sc_hd__nand2_1
X_3131_ hold98/A hold46/A hold80/A _4678_/Q _3246_/S0 _3246_/S1 VGND VGND VPWR VPWR
+ _3133_/B sky130_fd_sc_hd__mux4_1
XFILLER_67_324 VGND VGND VPWR VPWR sky130_fd_sc_hd__decap_4
XFILLER_94_121 VPWR VGND VPWR VGND sky130_ef_sc_hd__decap_12
XFILLER_67_335 VGND VGND VPWR VPWR sky130_fd_sc_hd__fill_1
XFILLER_94_165 VPWR VGND VPWR VGND sky130_ef_sc_hd__decap_12
X_3062_ _3007_/A _3037_/Y _3039_/B VGND VGND VPWR VPWR _3062_/Y sky130_fd_sc_hd__o21ai_1
XFILLER_48_560 VPWR VGND VPWR VGND sky130_ef_sc_hd__decap_12
XFILLER_82_338 VGND VGND VPWR VPWR sky130_fd_sc_hd__fill_1
XTAP_TAPCELL_ROW_85_1166 VGND VPWR sky130_fd_sc_hd__tapvpwrvgnd_1
XFILLER_63_541 VPWR VGND VPWR VGND sky130_ef_sc_hd__decap_12
XTAP_TAPCELL_ROW_18_430 VGND VPWR sky130_fd_sc_hd__tapvpwrvgnd_1
XPHY_EDGE_ROW_35_Left_143 VGND VGND VPWR VPWR sky130_fd_sc_hd__decap_3
XFILLER_63_585 VPWR VGND VPWR VGND sky130_ef_sc_hd__decap_12
X_3964_ _3964_/A _3964_/B _3964_/C VGND VGND VPWR VPWR _3965_/B sky130_fd_sc_hd__nor3_1
Xclkbuf_leaf_15_clk clkload2/A VGND VGND VPWR VPWR _4764_/CLK sky130_fd_sc_hd__clkbuf_8
XFILLER_23_449 VGND VGND VPWR VPWR sky130_fd_sc_hd__fill_2
XFILLER_50_235 VPWR VGND VPWR VGND sky130_ef_sc_hd__decap_12
X_3895_ _4648_/Q _4584_/Q hold76/A hold45/A _3915_/S0 _3915_/S1 VGND VGND VPWR VPWR
+ _3897_/B sky130_fd_sc_hd__mux4_2
X_2915_ _2915_/A _2915_/B VGND VGND VPWR VPWR _2922_/A sky130_fd_sc_hd__nand2_1
XFILLER_50_268 VGND VGND VPWR VPWR sky130_fd_sc_hd__fill_1
X_2846_ _4535_/Q _2846_/B _2846_/C VGND VGND VPWR VPWR _2847_/B sky130_fd_sc_hd__and3_1
Xhold100 _4629_/Q VGND VGND VPWR VPWR hold100/X sky130_fd_sc_hd__dlygate4sd3_1
X_2777_ _4500_/Q _2777_/B VGND VGND VPWR VPWR _2778_/B sky130_fd_sc_hd__nor2_1
XTAP_TAPCELL_ROW_96_1284 VGND VPWR sky130_fd_sc_hd__tapvpwrvgnd_1
X_4516_ _4517_/CLK _4516_/D fanout144/X VGND VGND VPWR VPWR _4516_/Q sky130_fd_sc_hd__dfrtp_2
Xhold122 _4560_/Q VGND VGND VPWR VPWR hold122/X sky130_fd_sc_hd__dlygate4sd3_1
XFILLER_2_309 VGND VGND VPWR VPWR sky130_fd_sc_hd__decap_4
Xhold133 _4717_/Q VGND VGND VPWR VPWR hold133/X sky130_fd_sc_hd__dlygate4sd3_1
Xhold144 _4422_/Q VGND VGND VPWR VPWR hold144/X sky130_fd_sc_hd__dlygate4sd3_1
XPHY_EDGE_ROW_44_Left_152 VGND VGND VPWR VPWR sky130_fd_sc_hd__decap_3
Xhold111 _4671_/Q VGND VGND VPWR VPWR hold111/X sky130_fd_sc_hd__dlygate4sd3_1
X_4447_ _4721_/CLK _4447_/D fanout157/X VGND VGND VPWR VPWR _4447_/Q sky130_fd_sc_hd__dfrtp_1
Xhold166 _4597_/Q VGND VGND VPWR VPWR hold166/X sky130_fd_sc_hd__dlygate4sd3_1
Xhold177 _4600_/Q VGND VGND VPWR VPWR hold177/X sky130_fd_sc_hd__dlygate4sd3_1
Xhold155 _4607_/Q VGND VGND VPWR VPWR hold155/X sky130_fd_sc_hd__dlygate4sd3_1
Xhold188 _4409_/Q VGND VGND VPWR VPWR hold188/X sky130_fd_sc_hd__dlygate4sd3_1
Xhold199 _4599_/Q VGND VGND VPWR VPWR hold199/X sky130_fd_sc_hd__dlygate4sd3_1
X_4378_ _4481_/CLK _4378_/D fanout152/X VGND VGND VPWR VPWR hold37/A sky130_fd_sc_hd__dfrtp_1
XFILLER_100_421 VPWR VGND VPWR VGND sky130_ef_sc_hd__decap_12
X_3329_ _3417_/A _3440_/A VGND VGND VPWR VPWR _3331_/A sky130_fd_sc_hd__xnor2_1
XFILLER_85_165 VGND VGND VPWR VPWR sky130_fd_sc_hd__decap_3
XFILLER_26_210 VGND VGND VPWR VPWR sky130_fd_sc_hd__fill_1
XFILLER_37_69 VGND VGND VPWR VPWR sky130_fd_sc_hd__decap_6
XPHY_EDGE_ROW_53_Left_161 VGND VGND VPWR VPWR sky130_fd_sc_hd__decap_3
XFILLER_26_265 VGND VGND VPWR VPWR sky130_fd_sc_hd__decap_8
XTAP_TAPCELL_ROW_105_1391 VGND VPWR sky130_fd_sc_hd__tapvpwrvgnd_1
XFILLER_81_393 VGND VGND VPWR VPWR sky130_fd_sc_hd__decap_6
XFILLER_14_449 VGND VGND VPWR VPWR sky130_fd_sc_hd__fill_2
XFILLER_53_57 VPWR VGND VPWR VGND sky130_ef_sc_hd__decap_12
XFILLER_10_633 VGND VGND VPWR VPWR sky130_fd_sc_hd__decap_4
XTAP_TAPCELL_ROW_24_499 VGND VPWR sky130_fd_sc_hd__tapvpwrvgnd_1
XPHY_EDGE_ROW_62_Left_170 VGND VGND VPWR VPWR sky130_fd_sc_hd__decap_3
XFILLER_5_169 VGND VGND VPWR VPWR sky130_fd_sc_hd__decap_8
XFILLER_96_419 VGND VGND VPWR VPWR sky130_fd_sc_hd__fill_1
XFILLER_78_65 VPWR VGND VPWR VGND sky130_ef_sc_hd__decap_12
XFILLER_103_281 VPWR VGND VPWR VGND sky130_ef_sc_hd__decap_12
XFILLER_94_53 VPWR VGND VPWR VGND sky130_ef_sc_hd__decap_12
XFILLER_92_625 VPWR VGND VPWR VGND sky130_ef_sc_hd__decap_12
XFILLER_94_97 VPWR VGND VPWR VGND sky130_ef_sc_hd__decap_12
XFILLER_17_232 VGND VGND VPWR VPWR sky130_fd_sc_hd__fill_1
XFILLER_45_552 VGND VGND VPWR VPWR sky130_fd_sc_hd__fill_2
XTAP_TAPCELL_ROW_15_400 VGND VPWR sky130_fd_sc_hd__tapvpwrvgnd_1
XFILLER_72_393 VGND VGND VPWR VPWR sky130_fd_sc_hd__decap_8
XFILLER_60_533 VPWR VGND VPWR VGND sky130_ef_sc_hd__decap_12
X_2700_ _2698_/X _2700_/B VGND VGND VPWR VPWR _2701_/B sky130_fd_sc_hd__and2b_1
X_3680_ _3735_/A _3732_/B VGND VGND VPWR VPWR _3683_/A sky130_fd_sc_hd__or2_1
X_2631_ _2712_/A _2631_/B VGND VGND VPWR VPWR _2633_/B sky130_fd_sc_hd__nand2b_1
X_2562_ hold143/X _4731_/Q _2566_/S VGND VGND VPWR VPWR _4485_/D sky130_fd_sc_hd__mux2_1
XFILLER_57_3 VPWR VGND VPWR VGND sky130_ef_sc_hd__decap_12
X_4301_ _4486_/Q _4301_/B VGND VGND VPWR VPWR _4301_/Y sky130_fd_sc_hd__xnor2_1
X_2493_ _2526_/A1 _2495_/B _2492_/X _2526_/B1 hold267/X VGND VGND VPWR VPWR _4459_/D
+ sky130_fd_sc_hd__a32o_1
X_4232_ _4707_/Q _4235_/C VGND VGND VPWR VPWR _4232_/X sky130_fd_sc_hd__or2_1
XFILLER_99_279 VGND VGND VPWR VPWR sky130_fd_sc_hd__fill_1
Xclkbuf_leaf_4_clk clkload1/A VGND VGND VPWR VPWR _4749_/CLK sky130_fd_sc_hd__clkbuf_8
XFILLER_95_441 VGND VGND VPWR VPWR sky130_fd_sc_hd__decap_6
X_4163_ _4169_/C VGND VGND VPWR VPWR _4163_/Y sky130_fd_sc_hd__inv_2
XFILLER_95_485 VPWR VGND VPWR VGND sky130_ef_sc_hd__decap_12
X_3114_ _3085_/B _3087_/B _3083_/X VGND VGND VPWR VPWR _3115_/B sky130_fd_sc_hd__a21o_1
XFILLER_67_165 VGND VGND VPWR VPWR sky130_fd_sc_hd__decap_3
X_4094_ _4363_/Q _4094_/B VGND VGND VPWR VPWR _4094_/Y sky130_fd_sc_hd__nand2_2
X_3045_ _3044_/B _3044_/C _4543_/Q VGND VGND VPWR VPWR _3046_/B sky130_fd_sc_hd__a21oi_1
X_3947_ _3947_/A _3947_/B VGND VGND VPWR VPWR _3948_/B sky130_fd_sc_hd__nand2_1
XFILLER_23_27 VPWR VGND VPWR VGND sky130_ef_sc_hd__decap_12
XFILLER_51_577 VGND VGND VPWR VPWR sky130_fd_sc_hd__decap_6
XTAP_TAPCELL_ROW_98_1313 VGND VPWR sky130_fd_sc_hd__tapvpwrvgnd_1
X_3878_ _3878_/A _3878_/B _3878_/C VGND VGND VPWR VPWR _3879_/B sky130_fd_sc_hd__or3_1
XTAP_TAPCELL_ROW_21_458 VGND VPWR sky130_fd_sc_hd__tapvpwrvgnd_1
X_2829_ _4501_/Q _2799_/B _2778_/A VGND VGND VPWR VPWR _2829_/X sky130_fd_sc_hd__a21o_1
XFILLER_3_607 VGND VGND VPWR VPWR sky130_fd_sc_hd__decap_8
XFILLER_3_629 VGND VGND VPWR VPWR sky130_fd_sc_hd__decap_8
XFILLER_2_139 VGND VGND VPWR VPWR sky130_fd_sc_hd__fill_1
XFILLER_100_251 VGND VGND VPWR VPWR sky130_fd_sc_hd__fill_1
XFILLER_74_625 VPWR VGND VPWR VGND sky130_ef_sc_hd__decap_12
XFILLER_104_41 VPWR VGND VPWR VGND sky130_ef_sc_hd__decap_12
XTAP_TAPCELL_ROW_107_1420 VGND VPWR sky130_fd_sc_hd__tapvpwrvgnd_1
XFILLER_104_85 VPWR VGND VPWR VGND sky130_ef_sc_hd__decap_12
XFILLER_73_146 VGND VGND VPWR VPWR sky130_fd_sc_hd__fill_1
XTAP_TAPCELL_ROW_29_547 VGND VPWR sky130_fd_sc_hd__tapvpwrvgnd_1
XTAP_TAPCELL_ROW_57_856 VGND VPWR sky130_fd_sc_hd__tapvpwrvgnd_1
XFILLER_54_371 VGND VGND VPWR VPWR sky130_fd_sc_hd__decap_4
XFILLER_54_382 VPWR VGND VPWR VGND sky130_ef_sc_hd__decap_12
Xfanout50 _4026_/X VGND VGND VPWR VPWR _4137_/A1 sky130_fd_sc_hd__clkbuf_4
Xfanout61 fanout67/X VGND VGND VPWR VPWR _4238_/B1 sky130_fd_sc_hd__buf_2
Xfanout72 _2983_/B2 VGND VGND VPWR VPWR _4339_/B2 sky130_fd_sc_hd__clkbuf_4
Xfanout83 fanout86/X VGND VGND VPWR VPWR _2983_/A2 sky130_fd_sc_hd__clkbuf_2
XFILLER_80_77 VGND VGND VPWR VPWR sky130_fd_sc_hd__decap_6
Xfanout94 _2747_/A VGND VGND VPWR VPWR _3278_/B sky130_fd_sc_hd__buf_2
XFILLER_13_93 VPWR VGND VPWR VGND sky130_ef_sc_hd__decap_12
XFILLER_10_496 VGND VGND VPWR VPWR sky130_fd_sc_hd__fill_1
XFILLER_6_412 VGND VGND VPWR VPWR sky130_fd_sc_hd__decap_8
XTAP_TAPCELL_ROW_71_1018 VGND VPWR sky130_fd_sc_hd__tapvpwrvgnd_1
XFILLER_1_194 VGND VGND VPWR VPWR sky130_fd_sc_hd__fill_1
XFILLER_37_305 VPWR VGND VPWR VGND sky130_ef_sc_hd__decap_12
XFILLER_92_433 VPWR VGND VPWR VGND sky130_ef_sc_hd__decap_12
XFILLER_77_485 VPWR VGND VPWR VGND sky130_ef_sc_hd__decap_12
XFILLER_92_477 VPWR VGND VPWR VGND sky130_ef_sc_hd__decap_12
Xclkbuf_3_7__f_clk clkbuf_0_clk/X VGND VGND VPWR VPWR clkload6/A sky130_fd_sc_hd__clkbuf_16
XFILLER_18_585 VGND VGND VPWR VPWR sky130_fd_sc_hd__decap_3
XFILLER_45_371 VGND VGND VPWR VPWR sky130_fd_sc_hd__fill_2
XTAP_TAPCELL_ROW_82_1136 VGND VPWR sky130_fd_sc_hd__tapvpwrvgnd_1
X_3801_ _4758_/Q _3800_/C _4759_/Q VGND VGND VPWR VPWR _3802_/B sky130_fd_sc_hd__a21oi_1
XFILLER_60_385 VGND VGND VPWR VPWR sky130_fd_sc_hd__decap_4
X_3732_ _3735_/A _3732_/B _3732_/C VGND VGND VPWR VPWR _3732_/X sky130_fd_sc_hd__or3_1
Xclkload20 _4676_/CLK VGND VGND VPWR VPWR clkload20/Y sky130_fd_sc_hd__bufinv_16
X_3663_ _3664_/A _3664_/B _3689_/B VGND VGND VPWR VPWR _3663_/Y sky130_fd_sc_hd__o21ai_1
X_2614_ _4739_/Q _2615_/B VGND VGND VPWR VPWR _2712_/A sky130_fd_sc_hd__nor2_1
Xclkload42 _4721_/CLK VGND VGND VPWR VPWR clkload42/X sky130_fd_sc_hd__clkbuf_8
Xclkload31 _4531_/CLK VGND VGND VPWR VPWR clkload31/Y sky130_fd_sc_hd__inv_6
X_3594_ _3595_/B _3696_/A VGND VGND VPWR VPWR _3594_/Y sky130_fd_sc_hd__nand2b_1
XTAP_TAPCELL_ROW_93_1254 VGND VPWR sky130_fd_sc_hd__tapvpwrvgnd_1
X_2545_ _4475_/Q _4474_/Q _4473_/Q hold89/A VGND VGND VPWR VPWR _2545_/X sky130_fd_sc_hd__a31o_1
X_2476_ _2482_/B1 _2478_/B _2475_/X _2483_/B2 hold258/X VGND VGND VPWR VPWR _4454_/D
+ sky130_fd_sc_hd__a32o_1
XFILLER_87_249 VGND VGND VPWR VPWR sky130_fd_sc_hd__fill_1
X_4215_ _4215_/A _4215_/B VGND VGND VPWR VPWR _4218_/B sky130_fd_sc_hd__nor2_1
X_4146_ hold107/X _4026_/X _4148_/S VGND VGND VPWR VPWR _4674_/D sky130_fd_sc_hd__mux2_1
XFILLER_95_293 VPWR VGND VPWR VGND sky130_ef_sc_hd__decap_12
XFILLER_18_27 VGND VGND VPWR VPWR sky130_fd_sc_hd__fill_1
XFILLER_55_102 VGND VGND VPWR VPWR sky130_fd_sc_hd__fill_1
XFILLER_55_113 VGND VGND VPWR VPWR sky130_fd_sc_hd__fill_1
XFILLER_56_625 VPWR VGND VPWR VGND sky130_ef_sc_hd__decap_12
X_4077_ _4149_/B _4132_/A1 _4013_/Y _2352_/A hold48/X VGND VGND VPWR VPWR _4613_/D
+ sky130_fd_sc_hd__a32o_1
XFILLER_71_617 VPWR VGND VPWR VGND sky130_ef_sc_hd__decap_12
XTAP_TAPCELL_ROW_26_517 VGND VPWR sky130_fd_sc_hd__tapvpwrvgnd_1
X_3028_ _3028_/A _3028_/B _3028_/C VGND VGND VPWR VPWR _3028_/X sky130_fd_sc_hd__or3_1
XTAP_TAPCELL_ROW_54_826 VGND VPWR sky130_fd_sc_hd__tapvpwrvgnd_1
XFILLER_34_15 VPWR VGND VPWR VGND sky130_ef_sc_hd__decap_12
XFILLER_51_374 VGND VGND VPWR VPWR sky130_fd_sc_hd__fill_1
XTAP_TAPCELL_ROW_102_1350 VGND VPWR sky130_fd_sc_hd__tapvpwrvgnd_1
Xclkload3 clkload3/A VGND VGND VPWR VPWR clkload3/Y sky130_fd_sc_hd__inv_6
XFILLER_86_260 VGND VGND VPWR VPWR sky130_fd_sc_hd__decap_8
XFILLER_75_55 VGND VGND VPWR VPWR sky130_fd_sc_hd__fill_1
XTAP_TAPCELL_ROW_6_297 VGND VPWR sky130_fd_sc_hd__tapvpwrvgnd_1
XFILLER_74_477 VPWR VGND VPWR VGND sky130_ef_sc_hd__decap_12
XFILLER_27_393 VGND VGND VPWR VPWR sky130_fd_sc_hd__decap_6
XFILLER_42_363 VGND VGND VPWR VPWR sky130_fd_sc_hd__fill_1
XFILLER_10_260 VGND VGND VPWR VPWR sky130_fd_sc_hd__decap_4
XFILLER_6_253 VPWR VGND VPWR VGND sky130_ef_sc_hd__decap_12
XFILLER_6_242 VGND VGND VPWR VPWR sky130_fd_sc_hd__fill_1
XFILLER_97_503 VGND VGND VPWR VPWR sky130_fd_sc_hd__fill_1
X_2330_ input3/X _4718_/D VGND VGND VPWR VPWR _4729_/D sky130_fd_sc_hd__and2_1
X_2261_ _4480_/Q _4481_/Q _3554_/B2 VGND VGND VPWR VPWR _2261_/X sky130_fd_sc_hd__o21a_1
X_4000_ hold253/X _4728_/Q _4007_/S VGND VGND VPWR VPWR _4557_/D sky130_fd_sc_hd__mux2_1
XFILLER_65_422 VPWR VGND VPWR VGND sky130_ef_sc_hd__decap_12
X_2192_ _4453_/Q VGND VGND VPWR VPWR _2471_/A sky130_fd_sc_hd__inv_2
XFILLER_37_113 VGND VGND VPWR VPWR sky130_fd_sc_hd__decap_4
XFILLER_37_146 VGND VGND VPWR VPWR sky130_fd_sc_hd__decap_4
XPHY_EDGE_ROW_9_Left_117 VGND VGND VPWR VPWR sky130_fd_sc_hd__decap_3
XFILLER_53_617 VPWR VGND VPWR VGND sky130_ef_sc_hd__decap_12
XFILLER_21_503 VGND VGND VPWR VPWR sky130_fd_sc_hd__fill_1
X_4764_ _4764_/CLK _4764_/D fanout141/X VGND VGND VPWR VPWR _4764_/Q sky130_fd_sc_hd__dfrtp_2
X_3715_ _3716_/A _3718_/C _3716_/C VGND VGND VPWR VPWR _3715_/Y sky130_fd_sc_hd__o21ai_1
XTAP_TAPCELL_ROW_31_575 VGND VPWR sky130_fd_sc_hd__tapvpwrvgnd_1
X_4695_ _4699_/CLK _4695_/D fanout158/X VGND VGND VPWR VPWR _4695_/Q sky130_fd_sc_hd__dfrtp_2
X_3646_ _4538_/Q _3748_/B2 _3645_/Y _3794_/B2 VGND VGND VPWR VPWR _4538_/D sky130_fd_sc_hd__a22o_1
X_3577_ _3577_/A _3577_/B VGND VGND VPWR VPWR _3578_/B sky130_fd_sc_hd__nand2_1
XFILLER_88_525 VGND VGND VPWR VPWR sky130_fd_sc_hd__decap_6
X_2528_ _2531_/B VGND VGND VPWR VPWR _2528_/Y sky130_fd_sc_hd__inv_2
XFILLER_29_15 VPWR VGND VPWR VGND sky130_ef_sc_hd__decap_12
XFILLER_102_357 VGND VGND VPWR VPWR sky130_fd_sc_hd__decap_6
XFILLER_88_569 VPWR VGND VPWR VGND sky130_ef_sc_hd__decap_12
XFILLER_75_208 VGND VGND VPWR VPWR sky130_fd_sc_hd__fill_1
X_2459_ _2459_/A _2459_/B VGND VGND VPWR VPWR _2459_/Y sky130_fd_sc_hd__nand2_1
XFILLER_29_603 VGND VGND VPWR VPWR sky130_fd_sc_hd__decap_8
Xhold15 hold15/A VGND VGND VPWR VPWR hold15/X sky130_fd_sc_hd__dlygate4sd3_1
Xhold37 hold37/A VGND VGND VPWR VPWR hold37/X sky130_fd_sc_hd__dlygate4sd3_1
Xhold26 hold26/A VGND VGND VPWR VPWR hold26/X sky130_fd_sc_hd__dlygate4sd3_1
Xhold48 hold48/A VGND VGND VPWR VPWR hold48/X sky130_fd_sc_hd__dlygate4sd3_1
Xhold59 hold59/A VGND VGND VPWR VPWR hold59/X sky130_fd_sc_hd__dlygate4sd3_1
XFILLER_28_113 VGND VGND VPWR VPWR sky130_fd_sc_hd__fill_1
XTAP_TAPCELL_ROW_3_267 VGND VPWR sky130_fd_sc_hd__tapvpwrvgnd_1
X_4129_ hold194/X _4138_/A1 _4130_/S VGND VGND VPWR VPWR _4659_/D sky130_fd_sc_hd__mux2_1
XTAP_TAPCELL_ROW_67_973 VGND VPWR sky130_fd_sc_hd__tapvpwrvgnd_1
XTAP_TAPCELL_ROW_39_664 VGND VPWR sky130_fd_sc_hd__tapvpwrvgnd_1
XFILLER_56_477 VGND VGND VPWR VPWR sky130_fd_sc_hd__decap_6
XFILLER_71_447 VGND VGND VPWR VPWR sky130_fd_sc_hd__fill_1
XFILLER_24_330 VGND VGND VPWR VPWR sky130_fd_sc_hd__decap_3
XFILLER_71_469 VPWR VGND VPWR VGND sky130_ef_sc_hd__decap_12
XFILLER_24_363 VGND VGND VPWR VPWR sky130_fd_sc_hd__fill_1
XFILLER_61_57 VPWR VGND VPWR VGND sky130_ef_sc_hd__decap_12
XFILLER_8_529 VGND VGND VPWR VPWR sky130_fd_sc_hd__decap_3
XFILLER_79_503 VGND VGND VPWR VPWR sky130_fd_sc_hd__fill_1
XFILLER_10_83 VGND VGND VPWR VPWR sky130_fd_sc_hd__fill_1
XFILLER_86_65 VPWR VGND VPWR VGND sky130_ef_sc_hd__decap_12
XFILLER_19_113 VGND VGND VPWR VPWR sky130_fd_sc_hd__fill_1
XFILLER_47_400 VGND VGND VPWR VPWR sky130_fd_sc_hd__decap_6
XFILLER_19_81 VGND VGND VPWR VPWR sky130_fd_sc_hd__decap_8
XFILLER_62_414 VGND VGND VPWR VPWR sky130_fd_sc_hd__decap_6
XFILLER_19_157 VGND VGND VPWR VPWR sky130_fd_sc_hd__decap_8
XFILLER_35_606 VGND VGND VPWR VPWR sky130_fd_sc_hd__decap_8
XFILLER_35_628 VGND VGND VPWR VPWR sky130_fd_sc_hd__fill_1
XFILLER_30_333 VGND VGND VPWR VPWR sky130_fd_sc_hd__fill_2
X_3500_ _3476_/B _3480_/B _3476_/A VGND VGND VPWR VPWR _3506_/A sky130_fd_sc_hd__a21bo_1
X_4480_ _4481_/CLK _4480_/D fanout162/X VGND VGND VPWR VPWR _4480_/Q sky130_fd_sc_hd__dfrtp_1
XTAP_TAPCELL_ROW_77_1079 VGND VPWR sky130_fd_sc_hd__tapvpwrvgnd_1
X_3431_ _4744_/Q _3431_/B VGND VGND VPWR VPWR _3434_/A sky130_fd_sc_hd__xnor2_2
XTAP_TAPCELL_ROW_90_1224 VGND VPWR sky130_fd_sc_hd__tapvpwrvgnd_1
X_3362_ _3360_/Y _3361_/X _4526_/Q _3470_/B2 VGND VGND VPWR VPWR _4526_/D sky130_fd_sc_hd__a2bb2o_1
X_2313_ _2313_/A _2313_/B _2313_/C _2312_/X VGND VGND VPWR VPWR _2313_/X sky130_fd_sc_hd__or4b_1
XFILLER_85_517 VPWR VGND VPWR VGND sky130_ef_sc_hd__decap_12
X_3293_ _3293_/A _3293_/B VGND VGND VPWR VPWR _3294_/B sky130_fd_sc_hd__xor2_1
X_2244_ hold10/X _2238_/Y _2566_/S VGND VGND VPWR VPWR _4358_/D sky130_fd_sc_hd__a21o_1
XFILLER_38_411 VGND VGND VPWR VPWR sky130_fd_sc_hd__decap_8
XFILLER_93_561 VPWR VGND VPWR VGND sky130_ef_sc_hd__decap_12
XFILLER_65_274 VGND VGND VPWR VPWR sky130_fd_sc_hd__decap_6
XTAP_TAPCELL_ROW_0_226 VGND VPWR sky130_fd_sc_hd__tapvpwrvgnd_1
XTAP_TAPCELL_ROW_88_1197 VGND VPWR sky130_fd_sc_hd__tapvpwrvgnd_1
XTAP_TAPCELL_ROW_64_932 VGND VPWR sky130_fd_sc_hd__tapvpwrvgnd_1
XTAP_TAPCELL_ROW_0_237 VGND VPWR sky130_fd_sc_hd__tapvpwrvgnd_1
XTAP_TAPCELL_ROW_36_623 VGND VPWR sky130_fd_sc_hd__tapvpwrvgnd_1
XFILLER_53_447 VGND VGND VPWR VPWR sky130_fd_sc_hd__fill_1
XFILLER_15_39 VPWR VGND VPWR VGND sky130_ef_sc_hd__decap_12
XFILLER_21_311 VGND VGND VPWR VPWR sky130_fd_sc_hd__fill_2
XFILLER_31_27 VPWR VGND VPWR VGND sky130_ef_sc_hd__decap_12
X_4747_ _4749_/CLK _4747_/D fanout127/X VGND VGND VPWR VPWR _4747_/Q sky130_fd_sc_hd__dfrtp_4
XFILLER_107_405 VPWR VGND VPWR VGND sky130_ef_sc_hd__decap_12
X_4678_ _4679_/CLK _4678_/D fanout139/X VGND VGND VPWR VPWR _4678_/Q sky130_fd_sc_hd__dfrtp_1
XFILLER_107_449 VPWR VGND VPWR VGND sky130_ef_sc_hd__decap_12
X_3629_ _3629_/A _3629_/B VGND VGND VPWR VPWR _3629_/X sky130_fd_sc_hd__or2_1
XTAP_TAPCELL_ROW_8_315 VGND VPWR sky130_fd_sc_hd__tapvpwrvgnd_1
XFILLER_0_237 VPWR VGND VPWR VGND sky130_ef_sc_hd__decap_12
XFILLER_0_204 VPWR VGND VPWR VGND sky130_ef_sc_hd__decap_12
XFILLER_102_121 VPWR VGND VPWR VGND sky130_ef_sc_hd__decap_12
XFILLER_102_165 VPWR VGND VPWR VGND sky130_ef_sc_hd__decap_12
XFILLER_71_222 VGND VGND VPWR VPWR sky130_fd_sc_hd__fill_2
XFILLER_12_344 VGND VGND VPWR VPWR sky130_fd_sc_hd__decap_4
XFILLER_24_193 VGND VGND VPWR VPWR sky130_fd_sc_hd__decap_3
XFILLER_12_399 VGND VGND VPWR VPWR sky130_fd_sc_hd__decap_6
XFILLER_99_609 VGND VGND VPWR VPWR sky130_fd_sc_hd__decap_6
XFILLER_21_93 VGND VGND VPWR VPWR sky130_fd_sc_hd__decap_8
XFILLER_79_333 VGND VGND VPWR VPWR sky130_fd_sc_hd__decap_3
XFILLER_67_517 VPWR VGND VPWR VGND sky130_ef_sc_hd__decap_12
XFILLER_75_561 VPWR VGND VPWR VGND sky130_ef_sc_hd__decap_12
XFILLER_90_531 VGND VGND VPWR VPWR sky130_fd_sc_hd__fill_1
XFILLER_35_447 VGND VGND VPWR VPWR sky130_fd_sc_hd__fill_1
XFILLER_47_285 VGND VGND VPWR VPWR sky130_fd_sc_hd__decap_6
X_3980_ _3970_/A _3970_/B _3968_/B VGND VGND VPWR VPWR _3982_/A sky130_fd_sc_hd__a21o_1
XTAP_TAPCELL_ROW_61_902 VGND VPWR sky130_fd_sc_hd__tapvpwrvgnd_1
X_2931_ _2877_/A _2879_/A _2898_/A _2896_/Y VGND VGND VPWR VPWR _2931_/X sky130_fd_sc_hd__a31o_1
XPHY_EDGE_ROW_99_Left_207 VGND VGND VPWR VPWR sky130_fd_sc_hd__decap_3
Xclkbuf_0_clk clk VGND VGND VPWR VPWR clkbuf_0_clk/X sky130_fd_sc_hd__clkbuf_16
XFILLER_87_3 VPWR VGND VPWR VGND sky130_ef_sc_hd__decap_12
XFILLER_30_141 VGND VGND VPWR VPWR sky130_fd_sc_hd__fill_1
X_4601_ clkload8/A _4601_/D fanout127/X VGND VGND VPWR VPWR _4601_/Q sky130_fd_sc_hd__dfrtp_1
X_2862_ _2862_/A _2862_/B VGND VGND VPWR VPWR _2865_/A sky130_fd_sc_hd__nand2_1
XTAP_TAPCELL_ROW_13_372 VGND VPWR sky130_fd_sc_hd__tapvpwrvgnd_1
X_2793_ _4533_/Q _2794_/B VGND VGND VPWR VPWR _2795_/A sky130_fd_sc_hd__nand2_1
XTAP_TAPCELL_ROW_41_681 VGND VPWR sky130_fd_sc_hd__tapvpwrvgnd_1
XFILLER_7_51 VGND VGND VPWR VPWR sky130_fd_sc_hd__decap_4
X_4532_ _4532_/CLK _4532_/D fanout154/X VGND VGND VPWR VPWR _4532_/Q sky130_fd_sc_hd__dfrtp_4
X_4463_ _4708_/CLK _4463_/D fanout164/X VGND VGND VPWR VPWR _4463_/Q sky130_fd_sc_hd__dfrtp_1
XFILLER_104_419 VGND VGND VPWR VPWR sky130_fd_sc_hd__fill_1
X_3414_ _3415_/A _3415_/B _3415_/C VGND VGND VPWR VPWR _3430_/B sky130_fd_sc_hd__a21o_1
XPHY_EDGE_ROW_15_Right_15 VGND VGND VPWR VPWR sky130_fd_sc_hd__decap_3
X_4394_ _4538_/CLK _4394_/D fanout167/X VGND VGND VPWR VPWR hold52/A sky130_fd_sc_hd__dfrtp_1
X_3345_ _3346_/A _3346_/B _3346_/C VGND VGND VPWR VPWR _3374_/B sky130_fd_sc_hd__a21o_1
XFILLER_100_625 VPWR VGND VPWR VGND sky130_ef_sc_hd__decap_12
X_3276_ _4522_/Q _3275_/B _4331_/B2 VGND VGND VPWR VPWR _3276_/Y sky130_fd_sc_hd__o21ai_1
X_2227_ _4589_/Q VGND VGND VPWR VPWR _2227_/Y sky130_fd_sc_hd__inv_2
XFILLER_38_241 VGND VGND VPWR VPWR sky130_fd_sc_hd__decap_8
XFILLER_26_27 VGND VGND VPWR VPWR sky130_fd_sc_hd__fill_1
XFILLER_26_414 VGND VGND VPWR VPWR sky130_fd_sc_hd__decap_6
XTAP_TAPCELL_ROW_49_770 VGND VPWR sky130_fd_sc_hd__tapvpwrvgnd_1
XFILLER_81_553 VGND VGND VPWR VPWR sky130_fd_sc_hd__decap_6
XFILLER_14_609 VGND VGND VPWR VPWR sky130_fd_sc_hd__fill_1
XPHY_EDGE_ROW_24_Right_24 VGND VGND VPWR VPWR sky130_fd_sc_hd__decap_3
XFILLER_81_597 VPWR VGND VPWR VGND sky130_ef_sc_hd__decap_12
XFILLER_13_119 VPWR VGND VPWR VGND sky130_ef_sc_hd__decap_12
XFILLER_41_428 VGND VGND VPWR VPWR sky130_fd_sc_hd__decap_4
XFILLER_53_277 VGND VGND VPWR VPWR sky130_fd_sc_hd__decap_3
XFILLER_34_491 VGND VGND VPWR VPWR sky130_fd_sc_hd__decap_4
XFILLER_42_15 VPWR VGND VPWR VGND sky130_ef_sc_hd__decap_12
XPHY_EDGE_ROW_33_Right_33 VGND VGND VPWR VPWR sky130_fd_sc_hd__decap_3
XFILLER_103_441 VGND VGND VPWR VPWR sky130_fd_sc_hd__decap_6
XFILLER_107_85 VPWR VGND VPWR VGND sky130_ef_sc_hd__decap_12
XFILLER_103_485 VPWR VGND VPWR VGND sky130_ef_sc_hd__decap_12
XFILLER_29_263 VPWR VGND VPWR VGND sky130_ef_sc_hd__decap_12
XFILLER_57_561 VPWR VGND VPWR VGND sky130_ef_sc_hd__decap_12
XFILLER_72_531 VGND VGND VPWR VPWR sky130_fd_sc_hd__fill_1
XFILLER_29_296 VGND VGND VPWR VPWR sky130_fd_sc_hd__decap_8
XPHY_EDGE_ROW_42_Right_42 VGND VGND VPWR VPWR sky130_fd_sc_hd__decap_3
XFILLER_83_55 VGND VGND VPWR VPWR sky130_fd_sc_hd__fill_1
XFILLER_17_447 VGND VGND VPWR VPWR sky130_fd_sc_hd__fill_1
XFILLER_32_406 VPWR VGND VPWR VGND sky130_ef_sc_hd__decap_12
XFILLER_9_602 VPWR VGND VPWR VGND sky130_ef_sc_hd__decap_12
XFILLER_12_141 VGND VGND VPWR VPWR sky130_fd_sc_hd__decap_6
XTAP_TAPCELL_ROW_10_342 VGND VPWR sky130_fd_sc_hd__tapvpwrvgnd_1
XPHY_EDGE_ROW_51_Right_51 VGND VGND VPWR VPWR sky130_fd_sc_hd__decap_3
XFILLER_8_189 VGND VGND VPWR VPWR sky130_fd_sc_hd__decap_6
XFILLER_99_417 VPWR VGND VPWR VGND sky130_ef_sc_hd__decap_12
XTAP_TAPCELL_ROW_74_1049 VGND VPWR sky130_fd_sc_hd__tapvpwrvgnd_1
XFILLER_4_373 VGND VGND VPWR VPWR sky130_fd_sc_hd__decap_3
X_3130_ hold226/X _4354_/A2 _3922_/A _4354_/B2 VGND VGND VPWR VPWR _4514_/D sky130_fd_sc_hd__a22o_1
XFILLER_79_163 VGND VGND VPWR VPWR sky130_fd_sc_hd__decap_4
XFILLER_94_133 VGND VGND VPWR VPWR sky130_fd_sc_hd__decap_6
XFILLER_94_177 VPWR VGND VPWR VGND sky130_ef_sc_hd__decap_12
X_3061_ _3061_/A _3061_/B VGND VGND VPWR VPWR _3061_/Y sky130_fd_sc_hd__nor2_1
XPHY_EDGE_ROW_60_Right_60 VGND VGND VPWR VPWR sky130_fd_sc_hd__decap_3
XFILLER_35_222 VGND VGND VPWR VPWR sky130_fd_sc_hd__fill_2
XFILLER_63_553 VGND VGND VPWR VPWR sky130_fd_sc_hd__decap_6
XTAP_TAPCELL_ROW_18_431 VGND VPWR sky130_fd_sc_hd__tapvpwrvgnd_1
XTAP_TAPCELL_ROW_46_740 VGND VPWR sky130_fd_sc_hd__tapvpwrvgnd_1
XTAP_TAPCELL_ROW_85_1167 VGND VPWR sky130_fd_sc_hd__tapvpwrvgnd_1
XFILLER_63_597 VPWR VGND VPWR VGND sky130_ef_sc_hd__decap_12
X_3963_ _3964_/A _3964_/B _3964_/C VGND VGND VPWR VPWR _3965_/A sky130_fd_sc_hd__o21a_1
XFILLER_50_247 VGND VGND VPWR VPWR sky130_fd_sc_hd__decap_4
X_3894_ _3913_/B _3894_/B VGND VGND VPWR VPWR _3897_/A sky130_fd_sc_hd__and2_1
X_2914_ _4538_/Q _2914_/B VGND VGND VPWR VPWR _2915_/B sky130_fd_sc_hd__or2_1
X_2845_ _2846_/B _2846_/C _4535_/Q VGND VGND VPWR VPWR _2871_/A sky130_fd_sc_hd__a21oi_1
XFILLER_12_29 VPWR VGND VPWR VGND sky130_ef_sc_hd__decap_12
X_4515_ _4517_/CLK _4515_/D fanout144/X VGND VGND VPWR VPWR _4515_/Q sky130_fd_sc_hd__dfrtp_2
Xhold101 _4647_/Q VGND VGND VPWR VPWR hold101/X sky130_fd_sc_hd__dlygate4sd3_1
X_2776_ _4500_/Q _2777_/B VGND VGND VPWR VPWR _2778_/A sky130_fd_sc_hd__and2_1
XPHY_EDGE_ROW_103_Right_103 VGND VGND VPWR VPWR sky130_fd_sc_hd__decap_3
XTAP_TAPCELL_ROW_96_1285 VGND VPWR sky130_fd_sc_hd__tapvpwrvgnd_1
Xhold134 _4573_/Q VGND VGND VPWR VPWR hold134/X sky130_fd_sc_hd__dlygate4sd3_1
Xhold123 _4670_/Q VGND VGND VPWR VPWR hold123/X sky130_fd_sc_hd__dlygate4sd3_1
Xhold112 _4637_/Q VGND VGND VPWR VPWR hold112/X sky130_fd_sc_hd__dlygate4sd3_1
Xhold156 _4585_/Q VGND VGND VPWR VPWR hold156/X sky130_fd_sc_hd__dlygate4sd3_1
X_4446_ _4721_/CLK _4446_/D fanout157/X VGND VGND VPWR VPWR hold66/A sky130_fd_sc_hd__dfrtp_1
Xhold167 _4379_/Q VGND VGND VPWR VPWR hold167/X sky130_fd_sc_hd__dlygate4sd3_1
Xhold145 _2407_/X VGND VGND VPWR VPWR _4422_/D sky130_fd_sc_hd__dlygate4sd3_1
Xhold178 _4483_/Q VGND VGND VPWR VPWR hold178/X sky130_fd_sc_hd__dlygate4sd3_1
Xhold189 _2394_/X VGND VGND VPWR VPWR _4409_/D sky130_fd_sc_hd__dlygate4sd3_1
X_4377_ _4536_/CLK _4377_/D fanout152/X VGND VGND VPWR VPWR hold42/A sky130_fd_sc_hd__dfrtp_1
XFILLER_86_601 VPWR VGND VPWR VGND sky130_ef_sc_hd__decap_12
X_3328_ _3417_/A _3440_/A VGND VGND VPWR VPWR _3328_/Y sky130_fd_sc_hd__nand2_1
XFILLER_100_433 VPWR VGND VPWR VGND sky130_ef_sc_hd__decap_12
XFILLER_85_133 VGND VGND VPWR VPWR sky130_fd_sc_hd__decap_3
XFILLER_37_15 VPWR VGND VPWR VGND sky130_ef_sc_hd__decap_12
XFILLER_100_477 VPWR VGND VPWR VGND sky130_ef_sc_hd__decap_12
X_3259_ _4740_/Q _3339_/B VGND VGND VPWR VPWR _3369_/B sky130_fd_sc_hd__nor2_1
XFILLER_54_531 VGND VGND VPWR VPWR sky130_fd_sc_hd__fill_1
XFILLER_66_391 VGND VGND VPWR VPWR sky130_fd_sc_hd__decap_3
XFILLER_81_372 VPWR VGND VPWR VGND sky130_ef_sc_hd__decap_12
XFILLER_41_203 VGND VGND VPWR VPWR sky130_fd_sc_hd__decap_8
XTAP_TAPCELL_ROW_105_1392 VGND VPWR sky130_fd_sc_hd__tapvpwrvgnd_1
XFILLER_41_225 VPWR VGND VPWR VGND sky130_ef_sc_hd__decap_12
XFILLER_53_69 VGND VGND VPWR VPWR sky130_fd_sc_hd__decap_8
XFILLER_41_258 VGND VGND VPWR VPWR sky130_fd_sc_hd__fill_1
XFILLER_22_483 VGND VGND VPWR VPWR sky130_fd_sc_hd__fill_1
XFILLER_89_461 VPWR VGND VPWR VGND sky130_ef_sc_hd__decap_12
XFILLER_78_77 VGND VGND VPWR VPWR sky130_fd_sc_hd__decap_6
XFILLER_103_293 VPWR VGND VPWR VGND sky130_ef_sc_hd__decap_12
XFILLER_94_65 VPWR VGND VPWR VGND sky130_ef_sc_hd__decap_12
XFILLER_91_169 VGND VGND VPWR VPWR sky130_fd_sc_hd__decap_3
XFILLER_91_147 VGND VGND VPWR VPWR sky130_fd_sc_hd__decap_6
XFILLER_27_81 VPWR VGND VPWR VGND sky130_ef_sc_hd__decap_12
XFILLER_45_564 VPWR VGND VPWR VGND sky130_ef_sc_hd__decap_12
XFILLER_60_501 VPWR VGND VPWR VGND sky130_ef_sc_hd__decap_12
XTAP_TAPCELL_ROW_15_401 VGND VPWR sky130_fd_sc_hd__tapvpwrvgnd_1
XFILLER_17_277 VGND VGND VPWR VPWR sky130_fd_sc_hd__decap_3
XFILLER_17_288 VGND VGND VPWR VPWR sky130_fd_sc_hd__decap_8
XTAP_TAPCELL_ROW_43_710 VGND VPWR sky130_fd_sc_hd__tapvpwrvgnd_1
XFILLER_60_545 VPWR VGND VPWR VGND sky130_ef_sc_hd__decap_12
XFILLER_60_589 VPWR VGND VPWR VGND sky130_ef_sc_hd__decap_12
XFILLER_13_461 VGND VGND VPWR VPWR sky130_fd_sc_hd__decap_3
X_2630_ _2595_/A _2594_/B _2615_/B _4739_/Q _2592_/X VGND VGND VPWR VPWR _2631_/B
+ sky130_fd_sc_hd__a221o_1
X_2561_ hold173/X _4730_/Q _2566_/S VGND VGND VPWR VPWR _4484_/D sky130_fd_sc_hd__mux2_1
XFILLER_99_225 VPWR VGND VPWR VGND sky130_ef_sc_hd__decap_12
X_2492_ _4459_/Q _2492_/B VGND VGND VPWR VPWR _2492_/X sky130_fd_sc_hd__or2_1
X_4300_ _4318_/A _4299_/Y _4297_/Y _2250_/A VGND VGND VPWR VPWR _4301_/B sky130_fd_sc_hd__a211o_1
XFILLER_4_41 VPWR VGND VPWR VGND sky130_ef_sc_hd__decap_12
X_4231_ _4238_/A1 _4228_/X _4230_/Y _4238_/B1 _4706_/Q VGND VGND VPWR VPWR _4706_/D
+ sky130_fd_sc_hd__a32o_1
XFILLER_68_601 VPWR VGND VPWR VGND sky130_ef_sc_hd__decap_12
XFILLER_4_85 VPWR VGND VPWR VGND sky130_ef_sc_hd__decap_12
X_4162_ _4685_/Q _4686_/Q _4687_/Q VGND VGND VPWR VPWR _4169_/C sky130_fd_sc_hd__and3_1
XFILLER_83_615 VGND VGND VPWR VPWR sky130_fd_sc_hd__fill_1
X_3113_ _3111_/X _3113_/B VGND VGND VPWR VPWR _3115_/A sky130_fd_sc_hd__nand2b_1
X_4093_ hold90/X _4735_/Q _4093_/S VGND VGND VPWR VPWR _4628_/D sky130_fd_sc_hd__mux2_1
XFILLER_95_497 VGND VGND VPWR VPWR sky130_fd_sc_hd__decap_6
XFILLER_67_177 VGND VGND VPWR VPWR sky130_fd_sc_hd__fill_1
X_3044_ _4543_/Q _3044_/B _3044_/C VGND VGND VPWR VPWR _3046_/A sky130_fd_sc_hd__and3_1
XFILLER_51_501 VGND VGND VPWR VPWR sky130_fd_sc_hd__decap_3
XFILLER_51_512 VGND VGND VPWR VPWR sky130_fd_sc_hd__decap_4
XFILLER_90_191 VGND VGND VPWR VPWR sky130_fd_sc_hd__decap_4
XFILLER_23_225 VGND VGND VPWR VPWR sky130_fd_sc_hd__decap_6
X_3946_ _3947_/A _3947_/B VGND VGND VPWR VPWR _3946_/Y sky130_fd_sc_hd__nor2_1
XFILLER_23_39 VPWR VGND VPWR VGND sky130_ef_sc_hd__decap_12
XTAP_TAPCELL_ROW_98_1314 VGND VPWR sky130_fd_sc_hd__tapvpwrvgnd_1
X_3877_ _3878_/A _3878_/B _3878_/C VGND VGND VPWR VPWR _3898_/B sky130_fd_sc_hd__o21ai_1
XTAP_TAPCELL_ROW_21_459 VGND VPWR sky130_fd_sc_hd__tapvpwrvgnd_1
X_2828_ _2855_/A _2828_/B VGND VGND VPWR VPWR _2834_/A sky130_fd_sc_hd__nand2_1
XFILLER_105_503 VGND VGND VPWR VPWR sky130_fd_sc_hd__fill_1
X_2759_ _2734_/A _2757_/A _2758_/B _2758_/X VGND VGND VPWR VPWR _3348_/C sky130_fd_sc_hd__a31oi_4
X_4429_ _4539_/CLK _4429_/D fanout169/X VGND VGND VPWR VPWR _4429_/Q sky130_fd_sc_hd__dfrtp_1
XFILLER_58_166 VGND VGND VPWR VPWR sky130_fd_sc_hd__decap_8
XFILLER_104_53 VPWR VGND VPWR VGND sky130_ef_sc_hd__decap_12
XFILLER_73_103 VGND VGND VPWR VPWR sky130_fd_sc_hd__decap_3
XTAP_TAPCELL_ROW_107_1421 VGND VPWR sky130_fd_sc_hd__tapvpwrvgnd_1
XTAP_TAPCELL_ROW_107_1410 VGND VPWR sky130_fd_sc_hd__tapvpwrvgnd_1
XFILLER_104_97 VPWR VGND VPWR VGND sky130_ef_sc_hd__decap_12
XFILLER_27_553 VGND VGND VPWR VPWR sky130_fd_sc_hd__decap_3
XTAP_TAPCELL_ROW_29_548 VGND VPWR sky130_fd_sc_hd__tapvpwrvgnd_1
XTAP_TAPCELL_ROW_57_857 VGND VPWR sky130_fd_sc_hd__tapvpwrvgnd_1
XFILLER_73_169 VGND VGND VPWR VPWR sky130_fd_sc_hd__decap_6
XFILLER_14_203 VPWR VGND VPWR VGND sky130_ef_sc_hd__decap_12
XFILLER_27_586 VGND VGND VPWR VPWR sky130_fd_sc_hd__decap_4
XFILLER_14_269 VGND VGND VPWR VPWR sky130_fd_sc_hd__decap_8
XFILLER_42_589 VPWR VGND VPWR VGND sky130_ef_sc_hd__decap_12
Xfanout40 _4256_/A1 VGND VGND VPWR VPWR _4265_/B sky130_fd_sc_hd__buf_2
Xfanout51 _4024_/X VGND VGND VPWR VPWR _4136_/A1 sky130_fd_sc_hd__clkbuf_4
Xfanout73 _3554_/B2 VGND VGND VPWR VPWR _2983_/B2 sky130_fd_sc_hd__clkbuf_2
Xfanout62 _2407_/A2 VGND VGND VPWR VPWR _2379_/A2 sky130_fd_sc_hd__buf_2
Xfanout95 _2837_/S1 VGND VGND VPWR VPWR _2747_/A sky130_fd_sc_hd__clkbuf_4
Xfanout84 fanout86/X VGND VGND VPWR VPWR _3470_/B2 sky130_fd_sc_hd__clkbuf_4
XFILLER_10_475 VGND VGND VPWR VPWR sky130_fd_sc_hd__fill_1
XTAP_TAPCELL_ROW_71_1008 VGND VPWR sky130_fd_sc_hd__tapvpwrvgnd_1
XFILLER_65_615 VGND VGND VPWR VPWR sky130_fd_sc_hd__fill_1
XFILLER_77_497 VGND VGND VPWR VPWR sky130_fd_sc_hd__decap_6
XFILLER_37_317 VGND VGND VPWR VPWR sky130_fd_sc_hd__decap_6
XFILLER_92_445 VPWR VGND VPWR VGND sky130_ef_sc_hd__decap_12
XFILLER_18_531 VGND VGND VPWR VPWR sky130_fd_sc_hd__fill_1
XFILLER_92_489 VPWR VGND VPWR VGND sky130_ef_sc_hd__decap_12
XFILLER_52_309 VGND VGND VPWR VPWR sky130_fd_sc_hd__fill_1
XTAP_TAPCELL_ROW_82_1137 VGND VPWR sky130_fd_sc_hd__tapvpwrvgnd_1
XFILLER_18_597 VGND VGND VPWR VPWR sky130_fd_sc_hd__fill_2
X_3800_ _4758_/Q _4759_/Q _3800_/C VGND VGND VPWR VPWR _3849_/B sky130_fd_sc_hd__and3_1
XFILLER_60_353 VGND VGND VPWR VPWR sky130_fd_sc_hd__fill_1
X_3731_ _3776_/B _3731_/B VGND VGND VPWR VPWR _3742_/A sky130_fd_sc_hd__and2_1
XFILLER_20_228 VGND VGND VPWR VPWR sky130_fd_sc_hd__fill_1
XFILLER_9_240 VGND VGND VPWR VPWR sky130_fd_sc_hd__fill_1
Xclkload10 _4740_/CLK VGND VGND VPWR VPWR clkload10/Y sky130_fd_sc_hd__inv_8
X_3662_ _4539_/Q _3662_/B VGND VGND VPWR VPWR _3689_/B sky130_fd_sc_hd__xor2_1
Xclkload21 _4756_/CLK VGND VGND VPWR VPWR clkload21/Y sky130_fd_sc_hd__clkinv_2
Xclkload43 _4693_/CLK VGND VGND VPWR VPWR clkload43/Y sky130_fd_sc_hd__clkinvlp_4
X_2613_ _4560_/Q _4592_/Q _4624_/Q _4656_/Q _3257_/A _3278_/B VGND VGND VPWR VPWR
+ _2615_/B sky130_fd_sc_hd__mux4_2
Xclkload32 _4532_/CLK VGND VGND VPWR VPWR clkload32/Y sky130_fd_sc_hd__inv_6
X_3593_ _3696_/A _3595_/B VGND VGND VPWR VPWR _3593_/X sky130_fd_sc_hd__and2b_1
X_2544_ _2550_/C VGND VGND VPWR VPWR _2544_/Y sky130_fd_sc_hd__inv_2
XTAP_TAPCELL_ROW_93_1255 VGND VPWR sky130_fd_sc_hd__tapvpwrvgnd_1
XPHY_EDGE_ROW_81_Left_189 VGND VGND VPWR VPWR sky130_fd_sc_hd__decap_3
X_2475_ _4454_/Q _2475_/B VGND VGND VPWR VPWR _2475_/X sky130_fd_sc_hd__or2_1
X_4214_ _4215_/A _4215_/B VGND VGND VPWR VPWR _4214_/Y sky130_fd_sc_hd__nand2_1
X_4145_ hold102/X _4024_/X _4148_/S VGND VGND VPWR VPWR _4673_/D sky130_fd_sc_hd__mux2_1
XFILLER_95_261 VPWR VGND VPWR VGND sky130_ef_sc_hd__decap_12
XFILLER_28_317 VGND VGND VPWR VPWR sky130_fd_sc_hd__fill_2
XFILLER_28_328 VGND VGND VPWR VPWR sky130_fd_sc_hd__decap_4
X_4076_ _4139_/A1 hold147/X _4076_/S VGND VGND VPWR VPWR _4612_/D sky130_fd_sc_hd__mux2_1
XFILLER_71_629 VGND VGND VPWR VPWR sky130_fd_sc_hd__decap_8
XTAP_TAPCELL_ROW_26_518 VGND VPWR sky130_fd_sc_hd__tapvpwrvgnd_1
X_3027_ _3027_/A _3027_/B VGND VGND VPWR VPWR _3028_/C sky130_fd_sc_hd__or2_1
XTAP_TAPCELL_ROW_54_827 VGND VPWR sky130_fd_sc_hd__tapvpwrvgnd_1
XFILLER_34_27 VGND VGND VPWR VPWR sky130_fd_sc_hd__fill_1
XFILLER_51_320 VGND VGND VPWR VPWR sky130_fd_sc_hd__decap_8
XPHY_EDGE_ROW_90_Left_198 VGND VGND VPWR VPWR sky130_fd_sc_hd__decap_3
XTAP_TAPCELL_ROW_102_1351 VGND VPWR sky130_fd_sc_hd__tapvpwrvgnd_1
X_3929_ _3974_/A _3929_/B VGND VGND VPWR VPWR _3935_/A sky130_fd_sc_hd__nor2_1
Xclkload4 clkload4/A VGND VGND VPWR VPWR clkload4/Y sky130_fd_sc_hd__clkinv_2
XFILLER_50_15 VPWR VGND VPWR VGND sky130_ef_sc_hd__decap_12
XFILLER_3_405 VGND VGND VPWR VPWR sky130_fd_sc_hd__decap_6
XFILLER_59_57 VPWR VGND VPWR VGND sky130_ef_sc_hd__decap_12
XFILLER_59_431 VGND VGND VPWR VPWR sky130_fd_sc_hd__decap_8
XFILLER_101_561 VPWR VGND VPWR VGND sky130_ef_sc_hd__decap_12
XFILLER_74_401 VGND VGND VPWR VPWR sky130_fd_sc_hd__decap_3
XTAP_TAPCELL_ROW_6_298 VGND VPWR sky130_fd_sc_hd__tapvpwrvgnd_1
XFILLER_19_328 VGND VGND VPWR VPWR sky130_fd_sc_hd__fill_1
XFILLER_74_489 VPWR VGND VPWR VGND sky130_ef_sc_hd__decap_12
XFILLER_15_545 VGND VGND VPWR VPWR sky130_fd_sc_hd__decap_3
XFILLER_91_55 VGND VGND VPWR VPWR sky130_fd_sc_hd__fill_1
XFILLER_15_556 VGND VGND VPWR VPWR sky130_fd_sc_hd__decap_4
XFILLER_6_287 VGND VGND VPWR VPWR sky130_fd_sc_hd__fill_1
XFILLER_6_276 VGND VGND VPWR VPWR sky130_fd_sc_hd__fill_1
XFILLER_97_559 VGND VGND VPWR VPWR sky130_fd_sc_hd__fill_1
X_2260_ _2356_/A _4769_/Q VGND VGND VPWR VPWR _3845_/A sky130_fd_sc_hd__nand2_2
X_2191_ hold79/A VGND VGND VPWR VPWR _4201_/A sky130_fd_sc_hd__inv_2
XFILLER_37_103 VGND VGND VPWR VPWR sky130_fd_sc_hd__fill_1
XFILLER_65_434 VPWR VGND VPWR VGND sky130_ef_sc_hd__decap_12
XFILLER_92_253 VGND VGND VPWR VPWR sky130_fd_sc_hd__decap_4
XFILLER_37_169 VPWR VGND VPWR VGND sky130_ef_sc_hd__decap_12
XFILLER_53_629 VGND VGND VPWR VPWR sky130_fd_sc_hd__decap_8
XFILLER_60_183 VGND VGND VPWR VPWR sky130_fd_sc_hd__fill_2
X_4763_ _4764_/CLK _4763_/D fanout141/X VGND VGND VPWR VPWR _4763_/Q sky130_fd_sc_hd__dfrtp_1
XFILLER_21_548 VGND VGND VPWR VPWR sky130_fd_sc_hd__decap_4
X_3714_ _3693_/A _3693_/B _3687_/A VGND VGND VPWR VPWR _3716_/C sky130_fd_sc_hd__a21oi_1
X_4694_ _4721_/CLK _4694_/D fanout158/X VGND VGND VPWR VPWR _4694_/Q sky130_fd_sc_hd__dfrtp_1
XTAP_TAPCELL_ROW_31_576 VGND VPWR sky130_fd_sc_hd__tapvpwrvgnd_1
XFILLER_20_29 VPWR VGND VPWR VGND sky130_ef_sc_hd__decap_12
X_3645_ _3645_/A _3664_/B VGND VGND VPWR VPWR _3645_/Y sky130_fd_sc_hd__nor2_1
X_3576_ _3546_/A _3546_/B _3574_/X VGND VGND VPWR VPWR _3577_/B sky130_fd_sc_hd__o21ai_1
X_2527_ _2529_/A _2529_/B VGND VGND VPWR VPWR _2531_/B sky130_fd_sc_hd__nor2_1
X_2458_ _2458_/A VGND VGND VPWR VPWR _2461_/B sky130_fd_sc_hd__inv_2
XPHY_EDGE_ROW_89_Right_89 VGND VGND VPWR VPWR sky130_fd_sc_hd__decap_3
Xhold38 hold38/A VGND VGND VPWR VPWR hold38/X sky130_fd_sc_hd__dlygate4sd3_1
Xhold27 hold27/A VGND VGND VPWR VPWR hold27/X sky130_fd_sc_hd__dlygate4sd3_1
XFILLER_29_27 VPWR VGND VPWR VGND sky130_ef_sc_hd__decap_12
Xhold16 hold16/A VGND VGND VPWR VPWR hold16/X sky130_fd_sc_hd__dlygate4sd3_1
XFILLER_96_581 VGND VGND VPWR VPWR sky130_fd_sc_hd__decap_6
X_2389_ hold232/X _2395_/A2 _2395_/B1 _4490_/Q VGND VGND VPWR VPWR _4404_/D sky130_fd_sc_hd__a22o_1
Xhold49 hold49/A VGND VGND VPWR VPWR hold49/X sky130_fd_sc_hd__dlygate4sd3_1
XFILLER_29_615 VGND VGND VPWR VPWR sky130_fd_sc_hd__fill_1
XTAP_TAPCELL_ROW_3_268 VGND VPWR sky130_fd_sc_hd__tapvpwrvgnd_1
X_4128_ hold165/X _4137_/A1 _4130_/S VGND VGND VPWR VPWR _4658_/D sky130_fd_sc_hd__mux2_1
XFILLER_28_147 VGND VGND VPWR VPWR sky130_fd_sc_hd__fill_1
XFILLER_56_456 VPWR VGND VPWR VGND sky130_ef_sc_hd__decap_12
XFILLER_83_253 VPWR VGND VPWR VGND sky130_ef_sc_hd__decap_12
XTAP_TAPCELL_ROW_67_974 VGND VPWR sky130_fd_sc_hd__tapvpwrvgnd_1
XFILLER_16_309 VGND VGND VPWR VPWR sky130_fd_sc_hd__fill_2
XTAP_TAPCELL_ROW_39_665 VGND VPWR sky130_fd_sc_hd__tapvpwrvgnd_1
XFILLER_45_15 VPWR VGND VPWR VGND sky130_ef_sc_hd__decap_12
X_4059_ _4140_/B _4113_/C _4068_/D _4131_/D VGND VGND VPWR VPWR _4067_/S sky130_fd_sc_hd__or4b_4
XFILLER_71_437 VGND VGND VPWR VPWR sky130_fd_sc_hd__decap_3
XFILLER_24_353 VGND VGND VPWR VPWR sky130_fd_sc_hd__fill_2
XPHY_EDGE_ROW_98_Right_98 VGND VGND VPWR VPWR sky130_fd_sc_hd__decap_3
XFILLER_61_69 VGND VGND VPWR VPWR sky130_fd_sc_hd__decap_3
XFILLER_20_570 VPWR VGND VPWR VGND sky130_ef_sc_hd__decap_12
XFILLER_3_246 VPWR VGND VPWR VGND sky130_ef_sc_hd__decap_12
XFILLER_3_268 VPWR VGND VPWR VGND sky130_ef_sc_hd__decap_12
XFILLER_79_559 VGND VGND VPWR VPWR sky130_fd_sc_hd__fill_1
XFILLER_86_77 VGND VGND VPWR VPWR sky130_fd_sc_hd__decap_6
XFILLER_59_261 VGND VGND VPWR VPWR sky130_fd_sc_hd__decap_3
XFILLER_101_391 VGND VGND VPWR VPWR sky130_fd_sc_hd__fill_1
XFILLER_47_456 VGND VGND VPWR VPWR sky130_fd_sc_hd__decap_4
XFILLER_74_253 VPWR VGND VPWR VGND sky130_ef_sc_hd__decap_12
XFILLER_30_301 VGND VGND VPWR VPWR sky130_fd_sc_hd__decap_6
XFILLER_35_81 VGND VGND VPWR VPWR sky130_fd_sc_hd__decap_4
XFILLER_30_323 VGND VGND VPWR VPWR sky130_fd_sc_hd__fill_1
XFILLER_30_378 VGND VGND VPWR VPWR sky130_fd_sc_hd__fill_2
X_3430_ _3430_/A _3430_/B VGND VGND VPWR VPWR _3436_/A sky130_fd_sc_hd__nand2_1
X_3361_ _3357_/Y _3358_/X _3359_/X _3468_/A VGND VGND VPWR VPWR _3361_/X sky130_fd_sc_hd__a31o_1
XTAP_TAPCELL_ROW_90_1225 VGND VPWR sky130_fd_sc_hd__tapvpwrvgnd_1
X_2312_ _4204_/A _4455_/Q _2312_/C VGND VGND VPWR VPWR _2312_/X sky130_fd_sc_hd__or3_1
XFILLER_32_3 VPWR VGND VPWR VGND sky130_ef_sc_hd__decap_12
XFILLER_2_290 VGND VGND VPWR VPWR sky130_fd_sc_hd__fill_1
X_3292_ _3366_/A _3481_/A VGND VGND VPWR VPWR _3293_/B sky130_fd_sc_hd__xnor2_1
XFILLER_85_529 VPWR VGND VPWR VGND sky130_ef_sc_hd__decap_12
XFILLER_78_581 VGND VGND VPWR VPWR sky130_fd_sc_hd__decap_6
X_2243_ _4727_/Q _4356_/Q _4718_/Q VGND VGND VPWR VPWR _2566_/S sky130_fd_sc_hd__and3b_4
XFILLER_93_573 VPWR VGND VPWR VGND sky130_ef_sc_hd__decap_12
XTAP_TAPCELL_ROW_0_216 VGND VPWR sky130_fd_sc_hd__tapvpwrvgnd_1
XTAP_TAPCELL_ROW_0_227 VGND VPWR sky130_fd_sc_hd__tapvpwrvgnd_1
XTAP_TAPCELL_ROW_88_1198 VGND VPWR sky130_fd_sc_hd__tapvpwrvgnd_1
XFILLER_80_201 VGND VGND VPWR VPWR sky130_fd_sc_hd__decap_8
XTAP_TAPCELL_ROW_64_933 VGND VPWR sky130_fd_sc_hd__tapvpwrvgnd_1
XTAP_TAPCELL_ROW_36_624 VGND VPWR sky130_fd_sc_hd__tapvpwrvgnd_1
XFILLER_53_437 VGND VGND VPWR VPWR sky130_fd_sc_hd__fill_2
XFILLER_80_289 VPWR VGND VPWR VGND sky130_ef_sc_hd__decap_12
XFILLER_31_39 VPWR VGND VPWR VGND sky130_ef_sc_hd__decap_12
X_4746_ _4749_/CLK _4746_/D fanout127/X VGND VGND VPWR VPWR _4746_/Q sky130_fd_sc_hd__dfrtp_2
XFILLER_107_417 VGND VGND VPWR VPWR sky130_fd_sc_hd__decap_3
X_4677_ _4679_/CLK _4677_/D fanout138/X VGND VGND VPWR VPWR hold83/A sky130_fd_sc_hd__dfrtp_1
X_3628_ _3628_/A _3628_/B _3628_/C VGND VGND VPWR VPWR _3628_/X sky130_fd_sc_hd__or3_1
XTAP_TAPCELL_ROW_8_316 VGND VPWR sky130_fd_sc_hd__tapvpwrvgnd_1
XFILLER_0_216 VGND VGND VPWR VPWR sky130_fd_sc_hd__decap_8
X_3559_ _3558_/B _3558_/C _3676_/A VGND VGND VPWR VPWR _3628_/B sky130_fd_sc_hd__a21oi_1
XFILLER_102_133 VGND VGND VPWR VPWR sky130_fd_sc_hd__decap_6
XFILLER_0_249 VGND VGND VPWR VPWR sky130_fd_sc_hd__decap_3
XFILLER_102_177 VPWR VGND VPWR VGND sky130_ef_sc_hd__decap_12
XFILLER_29_423 VGND VGND VPWR VPWR sky130_fd_sc_hd__fill_2
XFILLER_29_445 VGND VGND VPWR VPWR sky130_fd_sc_hd__decap_3
XFILLER_16_139 VGND VGND VPWR VPWR sky130_fd_sc_hd__fill_1
XFILLER_71_245 VGND VGND VPWR VPWR sky130_fd_sc_hd__decap_8
XFILLER_8_316 VGND VGND VPWR VPWR sky130_fd_sc_hd__decap_8
XFILLER_4_511 VPWR VGND VPWR VGND sky130_ef_sc_hd__decap_12
XFILLER_98_109 VPWR VGND VPWR VGND sky130_ef_sc_hd__decap_12
XFILLER_67_529 VPWR VGND VPWR VGND sky130_ef_sc_hd__decap_12
XFILLER_75_573 VPWR VGND VPWR VGND sky130_ef_sc_hd__decap_12
XFILLER_62_223 VGND VGND VPWR VPWR sky130_fd_sc_hd__decap_3
XTAP_TAPCELL_ROW_61_903 VGND VPWR sky130_fd_sc_hd__tapvpwrvgnd_1
XFILLER_35_459 VGND VGND VPWR VPWR sky130_fd_sc_hd__decap_8
XFILLER_90_587 VGND VGND VPWR VPWR sky130_fd_sc_hd__fill_1
X_2930_ _2877_/A _2896_/Y _2898_/A _2878_/A _2878_/B VGND VGND VPWR VPWR _2930_/X
+ sky130_fd_sc_hd__o2111a_1
XFILLER_31_621 VPWR VGND VPWR VGND sky130_ef_sc_hd__decap_12
XFILLER_43_481 VGND VGND VPWR VPWR sky130_fd_sc_hd__fill_2
X_4600_ _4667_/CLK _4600_/D fanout124/X VGND VGND VPWR VPWR _4600_/Q sky130_fd_sc_hd__dfrtp_1
X_2861_ _4750_/Q _2861_/B VGND VGND VPWR VPWR _2862_/B sky130_fd_sc_hd__or2_1
XTAP_TAPCELL_ROW_13_373 VGND VPWR sky130_fd_sc_hd__tapvpwrvgnd_1
XFILLER_30_197 VPWR VGND VPWR VGND sky130_ef_sc_hd__decap_12
X_2792_ _4529_/Q _4538_/Q VGND VGND VPWR VPWR _2794_/B sky130_fd_sc_hd__xor2_1
XTAP_TAPCELL_ROW_41_682 VGND VPWR sky130_fd_sc_hd__tapvpwrvgnd_1
X_4531_ _4531_/CLK _4531_/D fanout150/X VGND VGND VPWR VPWR _4531_/Q sky130_fd_sc_hd__dfrtp_4
X_4462_ _4708_/CLK _4462_/D fanout164/X VGND VGND VPWR VPWR _4462_/Q sky130_fd_sc_hd__dfrtp_1
X_3413_ _3430_/A _3413_/B VGND VGND VPWR VPWR _3415_/C sky130_fd_sc_hd__nand2_1
X_4393_ _4536_/CLK _4393_/D fanout152/X VGND VGND VPWR VPWR hold13/A sky130_fd_sc_hd__dfrtp_1
X_3344_ _3344_/A VGND VGND VPWR VPWR _3346_/C sky130_fd_sc_hd__inv_2
X_3275_ _4522_/Q _3275_/B VGND VGND VPWR VPWR _3298_/A sky130_fd_sc_hd__and2_1
X_2226_ _4557_/Q VGND VGND VPWR VPWR _2226_/Y sky130_fd_sc_hd__inv_2
XTAP_TAPCELL_ROW_49_771 VGND VPWR sky130_fd_sc_hd__tapvpwrvgnd_1
XFILLER_53_234 VPWR VGND VPWR VGND sky130_ef_sc_hd__decap_12
XFILLER_42_27 VGND VGND VPWR VPWR sky130_fd_sc_hd__fill_1
X_4729_ _4734_/CLK _4729_/D fanout146/X VGND VGND VPWR VPWR _4729_/Q sky130_fd_sc_hd__dfrtp_2
XFILLER_107_225 VPWR VGND VPWR VGND sky130_ef_sc_hd__decap_12
XFILLER_107_53 VGND VGND VPWR VPWR sky130_fd_sc_hd__decap_3
XFILLER_1_558 VGND VGND VPWR VPWR sky130_fd_sc_hd__fill_2
XFILLER_107_97 VPWR VGND VPWR VGND sky130_ef_sc_hd__decap_12
XFILLER_67_57 VPWR VGND VPWR VGND sky130_ef_sc_hd__decap_12
XFILLER_103_497 VGND VGND VPWR VPWR sky130_fd_sc_hd__decap_6
XFILLER_88_197 VGND VGND VPWR VPWR sky130_fd_sc_hd__decap_3
XFILLER_57_573 VPWR VGND VPWR VGND sky130_ef_sc_hd__decap_12
XFILLER_91_329 VGND VGND VPWR VPWR sky130_fd_sc_hd__decap_6
XFILLER_29_275 VGND VGND VPWR VPWR sky130_fd_sc_hd__decap_4
XFILLER_72_587 VGND VGND VPWR VPWR sky130_fd_sc_hd__fill_1
XFILLER_32_418 VGND VGND VPWR VPWR sky130_fd_sc_hd__fill_2
XFILLER_16_83 VGND VGND VPWR VPWR sky130_fd_sc_hd__fill_1
XFILLER_9_614 VGND VGND VPWR VPWR sky130_fd_sc_hd__fill_2
XFILLER_40_473 VGND VGND VPWR VPWR sky130_fd_sc_hd__decap_3
XFILLER_12_197 VGND VGND VPWR VPWR sky130_fd_sc_hd__fill_1
XTAP_TAPCELL_ROW_10_343 VGND VPWR sky130_fd_sc_hd__tapvpwrvgnd_1
XFILLER_99_429 VPWR VGND VPWR VGND sky130_ef_sc_hd__decap_12
XFILLER_4_385 VGND VGND VPWR VPWR sky130_fd_sc_hd__decap_4
XFILLER_4_363 VGND VGND VPWR VPWR sky130_fd_sc_hd__fill_1
XFILLER_79_153 VGND VGND VPWR VPWR sky130_fd_sc_hd__fill_1
X_3060_ _3060_/A _3060_/B VGND VGND VPWR VPWR _3064_/A sky130_fd_sc_hd__nand2_1
XFILLER_67_337 VPWR VGND VPWR VGND sky130_ef_sc_hd__decap_12
XFILLER_94_189 VGND VGND VPWR VPWR sky130_fd_sc_hd__decap_6
XFILLER_75_370 VPWR VGND VPWR VGND sky130_ef_sc_hd__decap_12
XFILLER_90_340 VGND VGND VPWR VPWR sky130_fd_sc_hd__fill_2
XTAP_TAPCELL_ROW_18_432 VGND VPWR sky130_fd_sc_hd__tapvpwrvgnd_1
XTAP_TAPCELL_ROW_46_741 VGND VPWR sky130_fd_sc_hd__tapvpwrvgnd_1
XTAP_TAPCELL_ROW_85_1168 VGND VPWR sky130_fd_sc_hd__tapvpwrvgnd_1
XFILLER_23_418 VGND VGND VPWR VPWR sky130_fd_sc_hd__fill_1
XFILLER_35_267 VPWR VGND VPWR VGND sky130_ef_sc_hd__decap_12
XFILLER_35_289 VGND VGND VPWR VPWR sky130_fd_sc_hd__decap_3
X_3962_ _3962_/A _3962_/B VGND VGND VPWR VPWR _3964_/C sky130_fd_sc_hd__xor2_1
X_3893_ _4763_/Q _3893_/B VGND VGND VPWR VPWR _3894_/B sky130_fd_sc_hd__nand2_1
X_2913_ _4538_/Q _2914_/B VGND VGND VPWR VPWR _2915_/A sky130_fd_sc_hd__nand2_1
X_2844_ _4531_/Q _4540_/Q VGND VGND VPWR VPWR _2846_/C sky130_fd_sc_hd__nand2_1
X_4514_ _4517_/CLK _4514_/D fanout144/X VGND VGND VPWR VPWR _4514_/Q sky130_fd_sc_hd__dfrtp_1
X_2775_ _2775_/A _2775_/B VGND VGND VPWR VPWR _2777_/B sky130_fd_sc_hd__xnor2_1
XTAP_TAPCELL_ROW_96_1286 VGND VPWR sky130_fd_sc_hd__tapvpwrvgnd_1
Xhold102 _4673_/Q VGND VGND VPWR VPWR hold102/X sky130_fd_sc_hd__dlygate4sd3_1
Xhold113 _4443_/Q VGND VGND VPWR VPWR hold113/X sky130_fd_sc_hd__dlygate4sd3_1
Xhold124 _4372_/Q VGND VGND VPWR VPWR hold124/X sky130_fd_sc_hd__dlygate4sd3_1
Xhold135 _4367_/Q VGND VGND VPWR VPWR hold135/X sky130_fd_sc_hd__dlygate4sd3_1
Xhold157 _4586_/Q VGND VGND VPWR VPWR hold157/X sky130_fd_sc_hd__dlygate4sd3_1
X_4445_ _4693_/CLK _4445_/D fanout157/X VGND VGND VPWR VPWR _4445_/Q sky130_fd_sc_hd__dfrtp_1
Xhold146 _4661_/Q VGND VGND VPWR VPWR hold146/X sky130_fd_sc_hd__dlygate4sd3_1
Xhold168 _4662_/Q VGND VGND VPWR VPWR hold168/X sky130_fd_sc_hd__dlygate4sd3_1
Xhold179 _4667_/Q VGND VGND VPWR VPWR hold179/X sky130_fd_sc_hd__dlygate4sd3_1
X_4376_ _4481_/CLK _4376_/D fanout152/X VGND VGND VPWR VPWR hold33/A sky130_fd_sc_hd__dfrtp_1
XFILLER_100_401 VPWR VGND VPWR VGND sky130_ef_sc_hd__decap_12
XFILLER_86_613 VPWR VGND VPWR VGND sky130_ef_sc_hd__decap_12
X_3327_ _3417_/A _3440_/A VGND VGND VPWR VPWR _3327_/Y sky130_fd_sc_hd__nor2_1
XFILLER_100_445 VPWR VGND VPWR VGND sky130_ef_sc_hd__decap_12
XFILLER_85_156 VGND VGND VPWR VPWR sky130_fd_sc_hd__fill_1
X_3258_ _3278_/A _3278_/B _4738_/Q _4739_/Q VGND VGND VPWR VPWR _3339_/B sky130_fd_sc_hd__a31o_1
XFILLER_37_27 VPWR VGND VPWR VGND sky130_ef_sc_hd__decap_12
XFILLER_100_489 VPWR VGND VPWR VGND sky130_ef_sc_hd__decap_12
X_3189_ _4517_/Q _3189_/B VGND VGND VPWR VPWR _3191_/A sky130_fd_sc_hd__xor2_2
X_2209_ _4463_/Q VGND VGND VPWR VPWR _2209_/Y sky130_fd_sc_hd__inv_2
XFILLER_53_15 VPWR VGND VPWR VGND sky130_ef_sc_hd__decap_12
XFILLER_54_587 VGND VGND VPWR VPWR sky130_fd_sc_hd__fill_1
XTAP_TAPCELL_ROW_105_1382 VGND VPWR sky130_fd_sc_hd__tapvpwrvgnd_1
XFILLER_81_384 VGND VGND VPWR VPWR sky130_fd_sc_hd__decap_8
XFILLER_41_237 VGND VGND VPWR VPWR sky130_fd_sc_hd__fill_1
XTAP_TAPCELL_ROW_52_799 VGND VPWR sky130_fd_sc_hd__tapvpwrvgnd_1
XFILLER_5_138 VPWR VGND VPWR VGND sky130_ef_sc_hd__decap_12
XFILLER_103_261 VPWR VGND VPWR VGND sky130_ef_sc_hd__decap_12
XFILLER_89_473 VPWR VGND VPWR VGND sky130_ef_sc_hd__decap_12
XFILLER_76_123 VGND VGND VPWR VPWR sky130_fd_sc_hd__decap_8
XFILLER_49_337 VGND VGND VPWR VPWR sky130_fd_sc_hd__decap_8
XFILLER_94_77 VGND VGND VPWR VPWR sky130_fd_sc_hd__decap_6
XFILLER_91_126 VGND VGND VPWR VPWR sky130_fd_sc_hd__fill_1
XFILLER_17_223 VGND VGND VPWR VPWR sky130_fd_sc_hd__fill_1
XFILLER_72_373 VPWR VGND VPWR VGND sky130_ef_sc_hd__decap_12
XFILLER_60_513 VPWR VGND VPWR VGND sky130_ef_sc_hd__decap_12
XFILLER_27_93 VGND VGND VPWR VPWR sky130_fd_sc_hd__fill_1
XFILLER_32_204 VGND VGND VPWR VPWR sky130_fd_sc_hd__decap_6
XTAP_TAPCELL_ROW_43_700 VGND VPWR sky130_fd_sc_hd__tapvpwrvgnd_1
XFILLER_45_576 VPWR VGND VPWR VGND sky130_ef_sc_hd__decap_12
XFILLER_60_557 VPWR VGND VPWR VGND sky130_ef_sc_hd__decap_12
XTAP_TAPCELL_ROW_15_402 VGND VPWR sky130_fd_sc_hd__tapvpwrvgnd_1
XFILLER_32_226 VGND VGND VPWR VPWR sky130_fd_sc_hd__decap_6
XFILLER_13_484 VGND VGND VPWR VPWR sky130_fd_sc_hd__decap_6
XFILLER_9_444 VGND VGND VPWR VPWR sky130_fd_sc_hd__decap_4
XFILLER_43_81 VPWR VGND VPWR VGND sky130_ef_sc_hd__decap_12
XTAP_TAPCELL_ROW_23_490 VGND VPWR sky130_fd_sc_hd__tapvpwrvgnd_1
X_2560_ hold178/X _4729_/Q _2566_/S VGND VGND VPWR VPWR _4483_/D sky130_fd_sc_hd__mux2_1
X_2491_ _2491_/A _2492_/B VGND VGND VPWR VPWR _2495_/B sky130_fd_sc_hd__nand2_1
XFILLER_99_237 VPWR VGND VPWR VGND sky130_ef_sc_hd__decap_12
X_4230_ _4235_/C VGND VGND VPWR VPWR _4230_/Y sky130_fd_sc_hd__inv_2
XFILLER_68_613 VPWR VGND VPWR VGND sky130_ef_sc_hd__decap_12
XFILLER_4_53 VPWR VGND VPWR VGND sky130_ef_sc_hd__decap_12
X_4161_ _4206_/A1 _4159_/X _4160_/Y _4206_/B1 hold272/X VGND VGND VPWR VPWR _4686_/D
+ sky130_fd_sc_hd__a32o_1
XFILLER_4_97 VPWR VGND VPWR VGND sky130_ef_sc_hd__decap_12
X_3112_ _4760_/Q _3112_/B VGND VGND VPWR VPWR _3113_/B sky130_fd_sc_hd__or2_1
X_4092_ hold84/X _4734_/Q _4093_/S VGND VGND VPWR VPWR _4627_/D sky130_fd_sc_hd__mux2_1
X_3043_ _4539_/Q hold28/A VGND VGND VPWR VPWR _3044_/C sky130_fd_sc_hd__nand2_1
XFILLER_90_170 VGND VGND VPWR VPWR sky130_fd_sc_hd__fill_1
X_3945_ _3945_/A _3964_/B VGND VGND VPWR VPWR _3951_/A sky130_fd_sc_hd__or2_1
XTAP_TAPCELL_ROW_98_1315 VGND VPWR sky130_fd_sc_hd__tapvpwrvgnd_1
X_3876_ _3876_/A _3876_/B VGND VGND VPWR VPWR _3878_/C sky130_fd_sc_hd__xnor2_1
X_2827_ _4502_/Q _2827_/B VGND VGND VPWR VPWR _2828_/B sky130_fd_sc_hd__or2_1
X_2758_ _2758_/A _2758_/B VGND VGND VPWR VPWR _2758_/X sky130_fd_sc_hd__and2_1
XFILLER_105_559 VGND VGND VPWR VPWR sky130_fd_sc_hd__fill_1
X_4428_ _4513_/CLK _4428_/D fanout143/X VGND VGND VPWR VPWR _4428_/Q sky130_fd_sc_hd__dfrtp_1
X_2689_ _4496_/Q _3277_/B2 _3481_/A _2708_/B2 VGND VGND VPWR VPWR _4496_/D sky130_fd_sc_hd__a22o_1
XFILLER_48_15 VPWR VGND VPWR VGND sky130_ef_sc_hd__decap_12
X_4359_ _4735_/CLK _4359_/D fanout157/X VGND VGND VPWR VPWR _4786_/A sky130_fd_sc_hd__dfrtp_1
XFILLER_100_253 VPWR VGND VPWR VGND sky130_ef_sc_hd__decap_12
XFILLER_46_307 VGND VGND VPWR VPWR sky130_fd_sc_hd__fill_1
XPHY_EDGE_ROW_100_Left_208 VGND VGND VPWR VPWR sky130_fd_sc_hd__decap_3
XTAP_TAPCELL_ROW_107_1422 VGND VPWR sky130_fd_sc_hd__tapvpwrvgnd_1
XTAP_TAPCELL_ROW_107_1411 VGND VPWR sky130_fd_sc_hd__tapvpwrvgnd_1
XFILLER_104_65 VPWR VGND VPWR VGND sky130_ef_sc_hd__decap_12
XFILLER_27_532 VGND VGND VPWR VPWR sky130_fd_sc_hd__fill_1
XTAP_TAPCELL_ROW_29_549 VGND VPWR sky130_fd_sc_hd__tapvpwrvgnd_1
XTAP_TAPCELL_ROW_57_858 VGND VPWR sky130_fd_sc_hd__tapvpwrvgnd_1
XFILLER_14_215 VGND VGND VPWR VPWR sky130_fd_sc_hd__decap_8
Xfanout30 _4256_/A1 VGND VGND VPWR VPWR _2408_/B1 sky130_fd_sc_hd__clkbuf_4
Xfanout52 _4022_/X VGND VGND VPWR VPWR _4135_/A1 sky130_fd_sc_hd__clkbuf_4
Xfanout41 _2356_/X VGND VGND VPWR VPWR _4256_/A1 sky130_fd_sc_hd__buf_2
Xfanout63 _4262_/A VGND VGND VPWR VPWR _2407_/A2 sky130_fd_sc_hd__buf_2
Xfanout74 _2259_/X VGND VGND VPWR VPWR _3554_/B2 sky130_fd_sc_hd__clkbuf_4
XFILLER_13_51 VGND VGND VPWR VPWR sky130_fd_sc_hd__decap_4
XFILLER_10_421 VPWR VGND VPWR VGND sky130_ef_sc_hd__decap_12
Xfanout85 fanout86/X VGND VGND VPWR VPWR _2558_/B sky130_fd_sc_hd__clkbuf_2
Xfanout96 _2837_/S1 VGND VGND VPWR VPWR _3174_/S1 sky130_fd_sc_hd__clkbuf_4
XFILLER_89_55 VGND VGND VPWR VPWR sky130_fd_sc_hd__fill_1
XTAP_TAPCELL_ROW_71_1009 VGND VPWR sky130_fd_sc_hd__tapvpwrvgnd_1
XFILLER_104_581 VGND VGND VPWR VPWR sky130_fd_sc_hd__decap_6
XFILLER_89_281 VPWR VGND VPWR VGND sky130_ef_sc_hd__decap_12
XFILLER_92_457 VPWR VGND VPWR VGND sky130_ef_sc_hd__decap_12
XTAP_TAPCELL_ROW_82_1138 VGND VPWR sky130_fd_sc_hd__tapvpwrvgnd_1
XFILLER_33_546 VPWR VGND VPWR VGND sky130_ef_sc_hd__decap_12
XFILLER_60_321 VGND VGND VPWR VPWR sky130_fd_sc_hd__decap_8
X_3730_ _3730_/A _3730_/B _3730_/C _3730_/D VGND VGND VPWR VPWR _3731_/B sky130_fd_sc_hd__nand4_1
XFILLER_13_281 VGND VGND VPWR VPWR sky130_fd_sc_hd__decap_4
X_3661_ _3661_/A _3661_/B VGND VGND VPWR VPWR _3662_/B sky130_fd_sc_hd__xnor2_2
Xclkload22 _4758_/CLK VGND VGND VPWR VPWR clkload22/Y sky130_fd_sc_hd__inv_6
XFILLER_62_3 VPWR VGND VPWR VGND sky130_ef_sc_hd__decap_12
X_2612_ _2612_/A _2612_/B VGND VGND VPWR VPWR _2617_/A sky130_fd_sc_hd__xnor2_1
Xclkload11 _4737_/CLK VGND VGND VPWR VPWR clkload11/Y sky130_fd_sc_hd__clkinvlp_4
Xclkload44 _4727_/CLK VGND VGND VPWR VPWR clkload44/X sky130_fd_sc_hd__clkbuf_4
Xclkload33 _4533_/CLK VGND VGND VPWR VPWR clkload33/Y sky130_fd_sc_hd__clkinv_8
X_3592_ _3592_/A _3824_/A VGND VGND VPWR VPWR _3595_/B sky130_fd_sc_hd__xnor2_1
X_2543_ hold89/A _4475_/Q _4474_/Q _4473_/Q VGND VGND VPWR VPWR _2550_/C sky130_fd_sc_hd__and4_1
XTAP_TAPCELL_ROW_93_1256 VGND VPWR sky130_fd_sc_hd__tapvpwrvgnd_1
X_2474_ _4454_/Q _2475_/B VGND VGND VPWR VPWR _2478_/B sky130_fd_sc_hd__nand2_1
XFILLER_68_421 VGND VGND VPWR VPWR sky130_fd_sc_hd__decap_4
X_4213_ _4213_/A1 _4211_/X _4215_/B _4217_/B1 hold298/X VGND VGND VPWR VPWR _4701_/D
+ sky130_fd_sc_hd__a32o_1
X_4144_ hold126/X _4022_/X _4148_/S VGND VGND VPWR VPWR _4672_/D sky130_fd_sc_hd__mux2_1
XFILLER_95_273 VGND VGND VPWR VPWR sky130_fd_sc_hd__decap_6
XFILLER_18_29 VPWR VGND VPWR VGND sky130_ef_sc_hd__decap_12
XFILLER_28_307 VGND VGND VPWR VPWR sky130_fd_sc_hd__fill_1
XFILLER_83_446 VGND VGND VPWR VPWR sky130_fd_sc_hd__fill_2
X_4075_ _4138_/A1 hold131/X _4076_/S VGND VGND VPWR VPWR _4611_/D sky130_fd_sc_hd__mux2_1
XTAP_TAPCELL_ROW_26_519 VGND VPWR sky130_fd_sc_hd__tapvpwrvgnd_1
XTAP_TAPCELL_ROW_54_828 VGND VPWR sky130_fd_sc_hd__tapvpwrvgnd_1
X_3026_ _3054_/A _3026_/B VGND VGND VPWR VPWR _3104_/A sky130_fd_sc_hd__nand2_1
XTAP_TAPCELL_ROW_102_1352 VGND VPWR sky130_fd_sc_hd__tapvpwrvgnd_1
XFILLER_11_218 VGND VGND VPWR VPWR sky130_fd_sc_hd__decap_3
X_3928_ _4550_/Q _3928_/B VGND VGND VPWR VPWR _3929_/B sky130_fd_sc_hd__nor2_1
Xclkload5 clkload5/A VGND VGND VPWR VPWR clkload5/Y sky130_fd_sc_hd__inv_8
X_3859_ _3860_/A _3860_/B VGND VGND VPWR VPWR _3859_/X sky130_fd_sc_hd__and2_1
XFILLER_50_27 VGND VGND VPWR VPWR sky130_fd_sc_hd__fill_1
XFILLER_78_218 VPWR VGND VPWR VGND sky130_ef_sc_hd__decap_12
XFILLER_59_69 VGND VGND VPWR VPWR sky130_fd_sc_hd__decap_4
XFILLER_101_573 VPWR VGND VPWR VGND sky130_ef_sc_hd__decap_12
XFILLER_86_251 VGND VGND VPWR VPWR sky130_fd_sc_hd__fill_1
XTAP_TAPCELL_ROW_6_299 VGND VPWR sky130_fd_sc_hd__tapvpwrvgnd_1
XFILLER_75_57 VPWR VGND VPWR VGND sky130_ef_sc_hd__decap_12
XFILLER_54_181 VGND VGND VPWR VPWR sky130_fd_sc_hd__fill_1
XFILLER_54_192 VGND VGND VPWR VPWR sky130_fd_sc_hd__decap_4
XFILLER_24_83 VGND VGND VPWR VPWR sky130_fd_sc_hd__fill_1
XFILLER_10_251 VGND VGND VPWR VPWR sky130_fd_sc_hd__fill_1
XFILLER_10_295 VGND VGND VPWR VPWR sky130_fd_sc_hd__fill_2
XFILLER_97_505 VPWR VGND VPWR VGND sky130_ef_sc_hd__decap_12
XFILLER_77_240 VGND VGND VPWR VPWR sky130_fd_sc_hd__decap_4
X_2190_ _4455_/Q VGND VGND VPWR VPWR _2478_/A sky130_fd_sc_hd__inv_2
XFILLER_65_446 VGND VGND VPWR VPWR sky130_fd_sc_hd__fill_2
XFILLER_92_298 VGND VGND VPWR VPWR sky130_fd_sc_hd__decap_8
XFILLER_92_287 VGND VGND VPWR VPWR sky130_fd_sc_hd__decap_4
XFILLER_18_373 VGND VGND VPWR VPWR sky130_fd_sc_hd__fill_2
XFILLER_21_505 VGND VGND VPWR VPWR sky130_fd_sc_hd__decap_6
XFILLER_60_162 VGND VGND VPWR VPWR sky130_fd_sc_hd__fill_1
X_4762_ _4764_/CLK _4762_/D fanout140/X VGND VGND VPWR VPWR _4762_/Q sky130_fd_sc_hd__dfrtp_1
XFILLER_33_398 VGND VGND VPWR VPWR sky130_fd_sc_hd__fill_1
X_3713_ _4541_/Q _3713_/B VGND VGND VPWR VPWR _3718_/C sky130_fd_sc_hd__and2_1
X_4693_ _4693_/CLK _4693_/D fanout157/X VGND VGND VPWR VPWR _4693_/Q sky130_fd_sc_hd__dfrtp_1
XTAP_TAPCELL_ROW_31_577 VGND VPWR sky130_fd_sc_hd__tapvpwrvgnd_1
X_3644_ _3644_/A _3644_/B _3644_/C VGND VGND VPWR VPWR _3664_/B sky130_fd_sc_hd__nor3_1
XFILLER_106_109 VPWR VGND VPWR VGND sky130_ef_sc_hd__decap_12
X_3575_ _3575_/A _3575_/B _3575_/C VGND VGND VPWR VPWR _3577_/A sky130_fd_sc_hd__or3_1
X_2526_ _2526_/A1 _2529_/B _2525_/X _2526_/B1 _4469_/Q VGND VGND VPWR VPWR _4469_/D
+ sky130_fd_sc_hd__a32o_1
X_2457_ _2459_/A _2459_/B VGND VGND VPWR VPWR _2458_/A sky130_fd_sc_hd__nor2_1
Xhold28 hold28/A VGND VGND VPWR VPWR hold28/X sky130_fd_sc_hd__dlygate4sd3_1
XFILLER_29_39 VPWR VGND VPWR VGND sky130_ef_sc_hd__decap_12
Xhold17 hold17/A VGND VGND VPWR VPWR hold17/X sky130_fd_sc_hd__dlygate4sd3_1
X_2388_ _4403_/Q _2414_/A2 _2414_/B1 hold4/X VGND VGND VPWR VPWR hold5/A sky130_fd_sc_hd__a22o_1
Xhold39 hold39/A VGND VGND VPWR VPWR hold39/X sky130_fd_sc_hd__dlygate4sd3_1
XFILLER_56_402 VGND VGND VPWR VPWR sky130_fd_sc_hd__fill_2
XFILLER_83_221 VGND VGND VPWR VPWR sky130_fd_sc_hd__decap_3
XFILLER_68_295 VPWR VGND VPWR VGND sky130_ef_sc_hd__decap_12
X_4127_ hold99/X _4136_/A1 _4130_/S VGND VGND VPWR VPWR _4657_/D sky130_fd_sc_hd__mux2_1
XTAP_TAPCELL_ROW_3_269 VGND VPWR sky130_fd_sc_hd__tapvpwrvgnd_1
XFILLER_83_265 VPWR VGND VPWR VGND sky130_ef_sc_hd__decap_12
XTAP_TAPCELL_ROW_67_964 VGND VPWR sky130_fd_sc_hd__tapvpwrvgnd_1
X_4058_ _4139_/A1 hold206/X _4058_/S VGND VGND VPWR VPWR _4596_/D sky130_fd_sc_hd__mux2_1
XTAP_TAPCELL_ROW_39_666 VGND VPWR sky130_fd_sc_hd__tapvpwrvgnd_1
XFILLER_44_619 VPWR VGND VPWR VGND sky130_ef_sc_hd__decap_12
XFILLER_45_27 VPWR VGND VPWR VGND sky130_ef_sc_hd__decap_12
XFILLER_56_468 VGND VGND VPWR VPWR sky130_fd_sc_hd__decap_8
X_3009_ _3009_/A _3009_/B VGND VGND VPWR VPWR _3009_/X sky130_fd_sc_hd__or2_1
XFILLER_101_55 VGND VGND VPWR VPWR sky130_fd_sc_hd__fill_1
XFILLER_61_15 VPWR VGND VPWR VGND sky130_ef_sc_hd__decap_12
XFILLER_20_582 VGND VGND VPWR VPWR sky130_fd_sc_hd__decap_6
XFILLER_3_236 VGND VGND VPWR VPWR sky130_fd_sc_hd__decap_4
XFILLER_79_505 VPWR VGND VPWR VGND sky130_ef_sc_hd__decap_12
XFILLER_10_41 VPWR VGND VPWR VGND sky130_ef_sc_hd__decap_12
XFILLER_3_258 VGND VGND VPWR VPWR sky130_fd_sc_hd__decap_3
XFILLER_74_265 VGND VGND VPWR VPWR sky130_fd_sc_hd__decap_3
XFILLER_74_276 VGND VGND VPWR VPWR sky130_fd_sc_hd__decap_4
XFILLER_34_118 VGND VGND VPWR VPWR sky130_fd_sc_hd__decap_6
XFILLER_15_332 VGND VGND VPWR VPWR sky130_fd_sc_hd__decap_4
Xclkbuf_leaf_54_clk clkload0/A VGND VGND VPWR VPWR clkload9/A sky130_fd_sc_hd__clkbuf_8
XFILLER_15_376 VGND VGND VPWR VPWR sky130_fd_sc_hd__decap_8
XFILLER_7_553 VGND VGND VPWR VPWR sky130_fd_sc_hd__decap_6
X_3360_ _3357_/Y _3358_/X _3359_/X VGND VGND VPWR VPWR _3360_/Y sky130_fd_sc_hd__a21oi_1
XTAP_TAPCELL_ROW_90_1226 VGND VPWR sky130_fd_sc_hd__tapvpwrvgnd_1
X_2311_ _2311_/A _2311_/B VGND VGND VPWR VPWR _2313_/C sky130_fd_sc_hd__nor2_1
XFILLER_97_335 VGND VGND VPWR VPWR sky130_fd_sc_hd__fill_1
X_3291_ _3366_/A _3481_/A VGND VGND VPWR VPWR _3291_/Y sky130_fd_sc_hd__nand2_1
X_2242_ _2328_/B VGND VGND VPWR VPWR _4785_/A sky130_fd_sc_hd__inv_2
XFILLER_25_3 VPWR VGND VPWR VGND sky130_ef_sc_hd__decap_12
XFILLER_93_541 VPWR VGND VPWR VGND sky130_ef_sc_hd__decap_12
XFILLER_65_243 VGND VGND VPWR VPWR sky130_fd_sc_hd__fill_1
XTAP_TAPCELL_ROW_0_217 VGND VPWR sky130_fd_sc_hd__tapvpwrvgnd_1
XFILLER_53_405 VPWR VGND VPWR VGND sky130_ef_sc_hd__decap_12
XFILLER_93_585 VPWR VGND VPWR VGND sky130_ef_sc_hd__decap_12
XTAP_TAPCELL_ROW_88_1199 VGND VPWR sky130_fd_sc_hd__tapvpwrvgnd_1
XTAP_TAPCELL_ROW_64_934 VGND VPWR sky130_fd_sc_hd__tapvpwrvgnd_1
XTAP_TAPCELL_ROW_0_228 VGND VPWR sky130_fd_sc_hd__tapvpwrvgnd_1
XTAP_TAPCELL_ROW_36_625 VGND VPWR sky130_fd_sc_hd__tapvpwrvgnd_1
XFILLER_80_257 VGND VGND VPWR VPWR sky130_fd_sc_hd__decap_8
Xclkbuf_leaf_45_clk clkload4/A VGND VGND VPWR VPWR _4531_/CLK sky130_fd_sc_hd__clkbuf_8
XFILLER_53_449 VGND VGND VPWR VPWR sky130_fd_sc_hd__decap_3
XFILLER_61_460 VPWR VGND VPWR VGND sky130_ef_sc_hd__decap_12
XFILLER_21_357 VGND VGND VPWR VPWR sky130_fd_sc_hd__fill_2
X_4745_ clkload7/A _4745_/D fanout127/X VGND VGND VPWR VPWR _4745_/Q sky130_fd_sc_hd__dfrtp_2
X_4676_ _4676_/CLK _4676_/D fanout135/X VGND VGND VPWR VPWR _4676_/Q sky130_fd_sc_hd__dfrtp_1
X_3627_ _3651_/B _3627_/B VGND VGND VPWR VPWR _3638_/A sky130_fd_sc_hd__and2_1
XTAP_TAPCELL_ROW_8_317 VGND VPWR sky130_fd_sc_hd__tapvpwrvgnd_1
X_3558_ _3676_/A _3558_/B _3558_/C VGND VGND VPWR VPWR _3606_/A sky130_fd_sc_hd__nand3_1
XFILLER_88_302 VGND VGND VPWR VPWR sky130_fd_sc_hd__decap_6
X_2509_ _2509_/A _2509_/B VGND VGND VPWR VPWR _2509_/Y sky130_fd_sc_hd__nand2_1
X_3489_ _4532_/Q _3489_/B VGND VGND VPWR VPWR _3491_/B sky130_fd_sc_hd__xor2_1
XFILLER_102_189 VGND VGND VPWR VPWR sky130_fd_sc_hd__decap_6
XFILLER_56_15 VPWR VGND VPWR VGND sky130_ef_sc_hd__decap_12
XFILLER_29_457 VGND VGND VPWR VPWR sky130_fd_sc_hd__fill_1
XFILLER_71_268 VGND VGND VPWR VPWR sky130_fd_sc_hd__fill_1
XFILLER_4_523 VGND VGND VPWR VPWR sky130_fd_sc_hd__fill_1
XFILLER_21_51 VGND VGND VPWR VPWR sky130_fd_sc_hd__decap_4
XFILLER_97_55 VGND VGND VPWR VPWR sky130_fd_sc_hd__fill_1
XTAP_TAPCELL_ROW_76_1070 VGND VPWR sky130_fd_sc_hd__tapvpwrvgnd_1
XFILLER_94_349 VPWR VGND VPWR VGND sky130_ef_sc_hd__decap_12
XFILLER_87_390 VGND VGND VPWR VPWR sky130_fd_sc_hd__fill_2
XFILLER_47_221 VGND VGND VPWR VPWR sky130_fd_sc_hd__decap_3
XFILLER_75_541 VPWR VGND VPWR VGND sky130_ef_sc_hd__decap_12
XFILLER_35_405 VGND VGND VPWR VPWR sky130_fd_sc_hd__decap_4
XFILLER_47_265 VGND VGND VPWR VPWR sky130_fd_sc_hd__decap_8
XFILLER_90_533 VPWR VGND VPWR VGND sky130_ef_sc_hd__decap_12
XFILLER_75_585 VPWR VGND VPWR VGND sky130_ef_sc_hd__decap_12
XFILLER_62_257 VGND VGND VPWR VPWR sky130_fd_sc_hd__fill_1
XFILLER_62_235 VPWR VGND VPWR VGND sky130_ef_sc_hd__decap_12
Xclkbuf_leaf_27_clk clkload6/A VGND VGND VPWR VPWR _4712_/CLK sky130_fd_sc_hd__clkbuf_8
XTAP_TAPCELL_ROW_61_904 VGND VPWR sky130_fd_sc_hd__tapvpwrvgnd_1
XFILLER_15_195 VGND VGND VPWR VPWR sky130_fd_sc_hd__fill_2
XFILLER_31_633 VGND VGND VPWR VPWR sky130_fd_sc_hd__decap_4
X_2860_ _4750_/Q _2861_/B VGND VGND VPWR VPWR _2862_/A sky130_fd_sc_hd__nand2_1
XTAP_TAPCELL_ROW_13_374 VGND VPWR sky130_fd_sc_hd__tapvpwrvgnd_1
X_2791_ _2810_/C _2791_/B VGND VGND VPWR VPWR _2807_/B sky130_fd_sc_hd__nand2_1
XTAP_TAPCELL_ROW_41_683 VGND VPWR sky130_fd_sc_hd__tapvpwrvgnd_1
X_4530_ _4531_/CLK _4530_/D fanout150/X VGND VGND VPWR VPWR _4530_/Q sky130_fd_sc_hd__dfrtp_4
X_4461_ _4708_/CLK _4461_/D fanout164/X VGND VGND VPWR VPWR _4461_/Q sky130_fd_sc_hd__dfrtp_2
X_3412_ _3412_/A _3412_/B VGND VGND VPWR VPWR _3413_/B sky130_fd_sc_hd__or2_1
X_4392_ _4481_/CLK _4392_/D fanout152/X VGND VGND VPWR VPWR hold31/A sky130_fd_sc_hd__dfrtp_1
X_3343_ _3343_/A _3343_/B VGND VGND VPWR VPWR _3344_/A sky130_fd_sc_hd__xnor2_1
X_3274_ _3274_/A _3274_/B VGND VGND VPWR VPWR _3275_/B sky130_fd_sc_hd__xnor2_1
X_2225_ _4654_/Q VGND VGND VPWR VPWR _2225_/Y sky130_fd_sc_hd__inv_2
XFILLER_26_29 VPWR VGND VPWR VGND sky130_ef_sc_hd__decap_12
XTAP_TAPCELL_ROW_49_772 VGND VPWR sky130_fd_sc_hd__tapvpwrvgnd_1
XFILLER_93_393 VPWR VGND VPWR VGND sky130_ef_sc_hd__decap_12
XPHY_EDGE_ROW_5_Right_5 VGND VGND VPWR VPWR sky130_fd_sc_hd__decap_3
XFILLER_53_246 VGND VGND VPWR VPWR sky130_fd_sc_hd__decap_6
XFILLER_21_110 VGND VGND VPWR VPWR sky130_fd_sc_hd__fill_2
XFILLER_34_471 VGND VGND VPWR VPWR sky130_fd_sc_hd__decap_4
XFILLER_21_154 VGND VGND VPWR VPWR sky130_fd_sc_hd__fill_1
X_2989_ _3009_/B _2989_/B VGND VGND VPWR VPWR _2997_/A sky130_fd_sc_hd__xnor2_1
X_4728_ _4734_/CLK _4728_/D fanout146/X VGND VGND VPWR VPWR _4728_/Q sky130_fd_sc_hd__dfrtp_2
XFILLER_107_237 VPWR VGND VPWR VGND sky130_ef_sc_hd__decap_12
XFILLER_107_215 VGND VGND VPWR VPWR sky130_fd_sc_hd__decap_8
X_4659_ _4661_/CLK _4659_/D fanout121/X VGND VGND VPWR VPWR _4659_/Q sky130_fd_sc_hd__dfrtp_1
XFILLER_1_526 VPWR VGND VPWR VGND sky130_ef_sc_hd__decap_12
XFILLER_69_390 VGND VGND VPWR VPWR sky130_fd_sc_hd__fill_2
XFILLER_67_69 VGND VGND VPWR VPWR sky130_fd_sc_hd__decap_4
XFILLER_29_210 VPWR VGND VPWR VGND sky130_ef_sc_hd__decap_12
XFILLER_29_232 VGND VGND VPWR VPWR sky130_fd_sc_hd__decap_3
XFILLER_57_541 VPWR VGND VPWR VGND sky130_ef_sc_hd__decap_12
XFILLER_57_585 VPWR VGND VPWR VGND sky130_ef_sc_hd__decap_12
XFILLER_83_57 VPWR VGND VPWR VGND sky130_ef_sc_hd__decap_12
XFILLER_72_533 VPWR VGND VPWR VGND sky130_ef_sc_hd__decap_12
XFILLER_17_449 VGND VGND VPWR VPWR sky130_fd_sc_hd__decap_4
XFILLER_8_103 VGND VGND VPWR VPWR sky130_fd_sc_hd__fill_1
XFILLER_52_290 VGND VGND VPWR VPWR sky130_fd_sc_hd__fill_2
XFILLER_12_187 VGND VGND VPWR VPWR sky130_fd_sc_hd__decap_8
XFILLER_12_176 VGND VGND VPWR VPWR sky130_fd_sc_hd__fill_2
XFILLER_40_485 VGND VGND VPWR VPWR sky130_fd_sc_hd__fill_1
XFILLER_32_61 VGND VGND VPWR VPWR sky130_fd_sc_hd__decap_3
XTAP_TAPCELL_ROW_10_344 VGND VPWR sky130_fd_sc_hd__tapvpwrvgnd_1
XFILLER_32_94 VGND VGND VPWR VPWR sky130_fd_sc_hd__decap_6
XFILLER_67_349 VGND VGND VPWR VPWR sky130_fd_sc_hd__fill_1
XFILLER_75_382 VGND VGND VPWR VPWR sky130_fd_sc_hd__decap_3
XFILLER_63_500 VGND VGND VPWR VPWR sky130_fd_sc_hd__decap_4
XFILLER_35_213 VGND VGND VPWR VPWR sky130_fd_sc_hd__fill_2
XFILLER_75_393 VPWR VGND VPWR VGND sky130_ef_sc_hd__decap_12
XTAP_TAPCELL_ROW_18_433 VGND VPWR sky130_fd_sc_hd__tapvpwrvgnd_1
XTAP_TAPCELL_ROW_46_742 VGND VPWR sky130_fd_sc_hd__tapvpwrvgnd_1
XFILLER_90_352 VGND VGND VPWR VPWR sky130_fd_sc_hd__fill_1
X_3961_ _4651_/Q _4587_/Q hold74/A hold54/A _3983_/S0 _3983_/S1 VGND VGND VPWR VPWR
+ _3962_/B sky130_fd_sc_hd__mux4_2
XTAP_TAPCELL_ROW_85_1169 VGND VPWR sky130_fd_sc_hd__tapvpwrvgnd_1
XFILLER_35_257 VGND VGND VPWR VPWR sky130_fd_sc_hd__decap_3
XFILLER_35_279 VGND VGND VPWR VPWR sky130_fd_sc_hd__fill_1
X_2912_ _3536_/A _4543_/Q VGND VGND VPWR VPWR _2914_/B sky130_fd_sc_hd__xor2_1
XFILLER_92_3 VPWR VGND VPWR VGND sky130_ef_sc_hd__decap_12
X_3892_ _4763_/Q _3893_/B VGND VGND VPWR VPWR _3913_/B sky130_fd_sc_hd__or2_1
X_2843_ _4531_/Q _4540_/Q VGND VGND VPWR VPWR _2846_/B sky130_fd_sc_hd__or2_1
X_2774_ _2819_/A _2774_/B VGND VGND VPWR VPWR _2775_/B sky130_fd_sc_hd__xnor2_1
X_4513_ _4513_/CLK _4513_/D fanout143/X VGND VGND VPWR VPWR _4513_/Q sky130_fd_sc_hd__dfrtp_2
Xhold114 _4624_/Q VGND VGND VPWR VPWR hold114/X sky130_fd_sc_hd__dlygate4sd3_1
Xhold125 _4786_/A VGND VGND VPWR VPWR hold125/X sky130_fd_sc_hd__dlygate4sd3_1
Xhold103 _4420_/Q VGND VGND VPWR VPWR hold103/X sky130_fd_sc_hd__dlygate4sd3_1
XTAP_TAPCELL_ROW_96_1287 VGND VPWR sky130_fd_sc_hd__tapvpwrvgnd_1
Xhold147 _4612_/Q VGND VGND VPWR VPWR hold147/X sky130_fd_sc_hd__dlygate4sd3_1
X_4444_ _4735_/CLK _4444_/D fanout157/X VGND VGND VPWR VPWR _4444_/Q sky130_fd_sc_hd__dfrtp_1
Xhold158 _4594_/Q VGND VGND VPWR VPWR hold158/X sky130_fd_sc_hd__dlygate4sd3_1
Xhold136 _4664_/Q VGND VGND VPWR VPWR hold136/X sky130_fd_sc_hd__dlygate4sd3_1
Xclkbuf_leaf_7_clk clkload2/A VGND VGND VPWR VPWR _4757_/CLK sky130_fd_sc_hd__clkbuf_8
X_4375_ _4481_/CLK _4375_/D fanout153/X VGND VGND VPWR VPWR hold53/A sky130_fd_sc_hd__dfrtp_1
Xhold169 _4601_/Q VGND VGND VPWR VPWR hold169/X sky130_fd_sc_hd__dlygate4sd3_1
XPHY_EDGE_ROW_13_Left_121 VGND VGND VPWR VPWR sky130_fd_sc_hd__decap_3
X_3326_ _3346_/B _3326_/B VGND VGND VPWR VPWR _3332_/A sky130_fd_sc_hd__nand2_1
XFILLER_100_413 VGND VGND VPWR VPWR sky130_fd_sc_hd__decap_6
XFILLER_86_625 VPWR VGND VPWR VGND sky130_ef_sc_hd__decap_12
XFILLER_85_113 VPWR VGND VPWR VGND sky130_ef_sc_hd__decap_12
XFILLER_100_457 VPWR VGND VPWR VGND sky130_ef_sc_hd__decap_12
X_3257_ _3257_/A _3278_/B VGND VGND VPWR VPWR _3300_/B sky130_fd_sc_hd__nand2_1
XFILLER_37_39 VPWR VGND VPWR VGND sky130_ef_sc_hd__decap_12
X_3188_ _4517_/Q _3189_/B VGND VGND VPWR VPWR _3188_/X sky130_fd_sc_hd__or2_1
XFILLER_26_202 VGND VGND VPWR VPWR sky130_fd_sc_hd__decap_8
X_2208_ hold60/A VGND VGND VPWR VPWR _2509_/A sky130_fd_sc_hd__inv_2
XFILLER_54_533 VPWR VGND VPWR VGND sky130_ef_sc_hd__decap_12
XFILLER_53_27 VPWR VGND VPWR VGND sky130_ef_sc_hd__decap_12
XTAP_TAPCELL_ROW_105_1383 VGND VPWR sky130_fd_sc_hd__tapvpwrvgnd_1
XPHY_EDGE_ROW_22_Left_130 VGND VGND VPWR VPWR sky130_fd_sc_hd__decap_3
XFILLER_22_474 VGND VGND VPWR VPWR sky130_fd_sc_hd__fill_2
XTAP_TAPCELL_ROW_73_1040 VGND VPWR sky130_fd_sc_hd__tapvpwrvgnd_1
XFILLER_1_334 VGND VGND VPWR VPWR sky130_fd_sc_hd__fill_2
XFILLER_1_356 VGND VGND VPWR VPWR sky130_fd_sc_hd__fill_1
XFILLER_103_273 VGND VGND VPWR VPWR sky130_fd_sc_hd__decap_6
XFILLER_89_485 VPWR VGND VPWR VGND sky130_ef_sc_hd__decap_12
XFILLER_17_246 VGND VGND VPWR VPWR sky130_fd_sc_hd__decap_3
XFILLER_72_363 VGND VGND VPWR VPWR sky130_fd_sc_hd__fill_1
XTAP_TAPCELL_ROW_43_701 VGND VPWR sky130_fd_sc_hd__tapvpwrvgnd_1
XFILLER_45_588 VPWR VGND VPWR VGND sky130_ef_sc_hd__decap_12
XFILLER_60_525 VGND VGND VPWR VPWR sky130_fd_sc_hd__decap_6
XFILLER_60_569 VPWR VGND VPWR VGND sky130_ef_sc_hd__decap_12
XFILLER_13_430 VPWR VGND VPWR VGND sky130_ef_sc_hd__decap_12
XFILLER_43_93 VGND VGND VPWR VPWR sky130_fd_sc_hd__decap_3
XTAP_TAPCELL_ROW_23_480 VGND VPWR sky130_fd_sc_hd__tapvpwrvgnd_1
XFILLER_99_205 VPWR VGND VPWR VGND sky130_ef_sc_hd__decap_12
X_2490_ _2526_/A1 _2487_/Y _2489_/Y _2526_/B1 hold286/X VGND VGND VPWR VPWR _4458_/D
+ sky130_fd_sc_hd__a32o_1
XFILLER_99_249 VPWR VGND VPWR VGND sky130_ef_sc_hd__decap_12
XFILLER_4_65 VPWR VGND VPWR VGND sky130_ef_sc_hd__decap_12
X_4160_ _4685_/Q _4686_/Q VGND VGND VPWR VPWR _4160_/Y sky130_fd_sc_hd__nand2_1
X_3111_ _4760_/Q _3112_/B VGND VGND VPWR VPWR _3111_/X sky130_fd_sc_hd__and2_1
XFILLER_68_625 VPWR VGND VPWR VGND sky130_ef_sc_hd__decap_12
XFILLER_67_113 VGND VGND VPWR VPWR sky130_fd_sc_hd__decap_4
XFILLER_67_102 VGND VGND VPWR VPWR sky130_fd_sc_hd__fill_2
X_4091_ hold139/X _4733_/Q _4093_/S VGND VGND VPWR VPWR _4626_/D sky130_fd_sc_hd__mux2_1
XFILLER_83_617 VPWR VGND VPWR VGND sky130_ef_sc_hd__decap_12
X_3042_ _4539_/Q hold28/A VGND VGND VPWR VPWR _3044_/B sky130_fd_sc_hd__or2_1
XFILLER_48_360 VGND VGND VPWR VPWR sky130_fd_sc_hd__fill_1
XFILLER_55_308 VGND VGND VPWR VPWR sky130_fd_sc_hd__fill_1
XFILLER_36_533 VGND VGND VPWR VPWR sky130_fd_sc_hd__fill_1
XFILLER_48_393 VGND VGND VPWR VPWR sky130_fd_sc_hd__decap_8
XFILLER_23_238 VGND VGND VPWR VPWR sky130_fd_sc_hd__fill_1
X_3944_ _3943_/A _3943_/B _3943_/C VGND VGND VPWR VPWR _3964_/B sky130_fd_sc_hd__a21oi_1
X_3875_ _3876_/A _3876_/B VGND VGND VPWR VPWR _3898_/A sky130_fd_sc_hd__nand2b_1
XFILLER_31_271 VGND VGND VPWR VPWR sky130_fd_sc_hd__decap_6
XTAP_TAPCELL_ROW_98_1305 VGND VPWR sky130_fd_sc_hd__tapvpwrvgnd_1
X_2826_ _4502_/Q _2827_/B VGND VGND VPWR VPWR _2855_/A sky130_fd_sc_hd__nand2_1
X_2757_ _2757_/A _2758_/B VGND VGND VPWR VPWR _2831_/A sky130_fd_sc_hd__nand2_1
XFILLER_105_505 VPWR VGND VPWR VGND sky130_ef_sc_hd__decap_12
XFILLER_2_109 VGND VGND VPWR VPWR sky130_fd_sc_hd__decap_3
X_2688_ _2688_/A _2688_/B VGND VGND VPWR VPWR _3481_/A sky130_fd_sc_hd__xor2_4
X_4427_ _4513_/CLK _4427_/D fanout143/X VGND VGND VPWR VPWR _4427_/Q sky130_fd_sc_hd__dfrtp_1
XFILLER_86_411 VGND VGND VPWR VPWR sky130_fd_sc_hd__decap_8
X_4358_ _4726_/CLK _4358_/D fanout160/X VGND VGND VPWR VPWR hold10/A sky130_fd_sc_hd__dfrtp_1
XFILLER_48_27 VGND VGND VPWR VPWR sky130_fd_sc_hd__fill_1
XFILLER_100_221 VPWR VGND VPWR VGND sky130_ef_sc_hd__decap_12
XFILLER_86_444 VPWR VGND VPWR VGND sky130_ef_sc_hd__decap_12
X_3309_ _3293_/A _3293_/B _3291_/Y VGND VGND VPWR VPWR _3310_/B sky130_fd_sc_hd__o21ai_1
X_4289_ hold53/A hold25/A hold32/A _4399_/Q _2427_/A _2427_/B VGND VGND VPWR VPWR
+ _4290_/B sky130_fd_sc_hd__mux4_1
XFILLER_100_265 VPWR VGND VPWR VGND sky130_ef_sc_hd__decap_12
XFILLER_86_477 VPWR VGND VPWR VGND sky130_ef_sc_hd__decap_12
XTAP_TAPCELL_ROW_107_1423 VGND VPWR sky130_fd_sc_hd__tapvpwrvgnd_1
XTAP_TAPCELL_ROW_107_1412 VGND VPWR sky130_fd_sc_hd__tapvpwrvgnd_1
XFILLER_104_77 VGND VGND VPWR VPWR sky130_fd_sc_hd__decap_6
XFILLER_64_15 VPWR VGND VPWR VGND sky130_ef_sc_hd__decap_12
XFILLER_39_393 VGND VGND VPWR VPWR sky130_fd_sc_hd__decap_8
XTAP_TAPCELL_ROW_57_859 VGND VPWR sky130_fd_sc_hd__tapvpwrvgnd_1
XFILLER_54_363 VGND VGND VPWR VPWR sky130_fd_sc_hd__fill_1
XFILLER_81_182 VGND VGND VPWR VPWR sky130_fd_sc_hd__decap_4
Xfanout20 _3522_/B VGND VGND VPWR VPWR _3283_/S sky130_fd_sc_hd__clkbuf_4
Xfanout31 _4256_/A1 VGND VGND VPWR VPWR _2375_/B1 sky130_fd_sc_hd__clkbuf_2
Xfanout42 _4149_/B VGND VGND VPWR VPWR _4155_/A1 sky130_fd_sc_hd__buf_2
Xfanout53 _4020_/X VGND VGND VPWR VPWR _4134_/A1 sky130_fd_sc_hd__clkbuf_4
Xfanout64 _2414_/A2 VGND VGND VPWR VPWR _2420_/A2 sky130_fd_sc_hd__buf_2
Xfanout97 _2837_/S1 VGND VGND VPWR VPWR _3246_/S1 sky130_fd_sc_hd__buf_2
XFILLER_10_433 VGND VGND VPWR VPWR sky130_fd_sc_hd__fill_1
Xfanout86 _2431_/Y VGND VGND VPWR VPWR fanout86/X sky130_fd_sc_hd__buf_2
Xfanout75 _4355_/B2 VGND VGND VPWR VPWR _4345_/B2 sky130_fd_sc_hd__clkbuf_4
XFILLER_10_477 VGND VGND VPWR VPWR sky130_fd_sc_hd__decap_6
XTAP_TAPCELL_ROW_20_450 VGND VPWR sky130_fd_sc_hd__tapvpwrvgnd_1
XFILLER_49_113 VGND VGND VPWR VPWR sky130_fd_sc_hd__decap_4
XFILLER_89_293 VPWR VGND VPWR VGND sky130_ef_sc_hd__decap_12
XFILLER_65_617 VPWR VGND VPWR VGND sky130_ef_sc_hd__decap_12
XFILLER_64_138 VGND VGND VPWR VPWR sky130_fd_sc_hd__fill_2
XFILLER_92_469 VGND VGND VPWR VPWR sky130_fd_sc_hd__decap_6
XFILLER_33_525 VGND VGND VPWR VPWR sky130_fd_sc_hd__decap_6
XTAP_TAPCELL_ROW_82_1139 VGND VPWR sky130_fd_sc_hd__tapvpwrvgnd_1
XFILLER_33_558 VGND VGND VPWR VPWR sky130_fd_sc_hd__fill_2
XFILLER_41_580 VPWR VGND VPWR VGND sky130_ef_sc_hd__decap_12
X_3660_ _3733_/B _3660_/B VGND VGND VPWR VPWR _3661_/B sky130_fd_sc_hd__xnor2_1
Xclkload23 _4679_/CLK VGND VGND VPWR VPWR clkload23/X sky130_fd_sc_hd__clkbuf_4
X_2611_ _2611_/A _2611_/B VGND VGND VPWR VPWR _2612_/B sky130_fd_sc_hd__nand2_1
Xclkload12 _4656_/CLK VGND VGND VPWR VPWR clkload12/X sky130_fd_sc_hd__clkbuf_8
Xclkload34 _4501_/CLK VGND VGND VPWR VPWR clkload34/Y sky130_fd_sc_hd__inv_8
X_3591_ _3578_/A _3578_/B _3573_/A VGND VGND VPWR VPWR _3605_/A sky130_fd_sc_hd__a21bo_1
Xclkload45 _4547_/CLK VGND VGND VPWR VPWR clkload45/Y sky130_fd_sc_hd__bufinv_16
XFILLER_55_3 VPWR VGND VPWR VGND sky130_ef_sc_hd__decap_12
X_2542_ _2432_/A _2540_/Y _2541_/X _3748_/B2 hold276/X VGND VGND VPWR VPWR _4475_/D
+ sky130_fd_sc_hd__a32o_1
XTAP_TAPCELL_ROW_93_1257 VGND VPWR sky130_fd_sc_hd__tapvpwrvgnd_1
X_2473_ _2475_/B _2472_/Y hold255/X _2483_/B2 VGND VGND VPWR VPWR _4453_/D sky130_fd_sc_hd__a2bb2o_1
X_4212_ _4701_/Q _4212_/B VGND VGND VPWR VPWR _4215_/B sky130_fd_sc_hd__nand2_1
X_4143_ hold111/X _4020_/X _4148_/S VGND VGND VPWR VPWR _4671_/D sky130_fd_sc_hd__mux2_1
XFILLER_83_414 VGND VGND VPWR VPWR sky130_fd_sc_hd__fill_1
XFILLER_68_477 VPWR VGND VPWR VGND sky130_ef_sc_hd__decap_12
X_4074_ _4137_/A1 hold174/X _4076_/S VGND VGND VPWR VPWR _4610_/D sky130_fd_sc_hd__mux2_1
X_3025_ _4510_/Q _3025_/B VGND VGND VPWR VPWR _3026_/B sky130_fd_sc_hd__or2_1
XFILLER_71_609 VGND VGND VPWR VPWR sky130_fd_sc_hd__decap_6
XTAP_TAPCELL_ROW_54_829 VGND VPWR sky130_fd_sc_hd__tapvpwrvgnd_1
XFILLER_34_29 VPWR VGND VPWR VGND sky130_ef_sc_hd__decap_12
XFILLER_51_333 VGND VGND VPWR VPWR sky130_fd_sc_hd__decap_3
XTAP_TAPCELL_ROW_102_1353 VGND VPWR sky130_fd_sc_hd__tapvpwrvgnd_1
X_3927_ _4550_/Q _3928_/B VGND VGND VPWR VPWR _3974_/A sky130_fd_sc_hd__and2_1
X_3858_ _3858_/A _3967_/B VGND VGND VPWR VPWR _3860_/B sky130_fd_sc_hd__xor2_1
Xclkload6 clkload6/A VGND VGND VPWR VPWR clkload6/Y sky130_fd_sc_hd__inv_8
X_3789_ _3791_/A _3791_/B VGND VGND VPWR VPWR _3789_/Y sky130_fd_sc_hd__nand2_1
X_2809_ _2720_/A _2720_/B _2808_/X VGND VGND VPWR VPWR _2813_/B sky130_fd_sc_hd__a21o_1
XFILLER_105_335 VGND VGND VPWR VPWR sky130_fd_sc_hd__fill_1
XFILLER_59_15 VPWR VGND VPWR VGND sky130_ef_sc_hd__decap_12
XFILLER_101_541 VPWR VGND VPWR VGND sky130_ef_sc_hd__decap_12
XFILLER_101_585 VPWR VGND VPWR VGND sky130_ef_sc_hd__decap_12
XFILLER_47_617 VPWR VGND VPWR VGND sky130_ef_sc_hd__decap_12
XFILLER_75_69 VPWR VGND VPWR VGND sky130_ef_sc_hd__decap_12
XFILLER_15_503 VGND VGND VPWR VPWR sky130_fd_sc_hd__fill_1
XFILLER_61_119 VGND VGND VPWR VPWR sky130_fd_sc_hd__fill_1
XFILLER_91_57 VPWR VGND VPWR VGND sky130_ef_sc_hd__decap_12
XFILLER_42_388 VGND VGND VPWR VPWR sky130_fd_sc_hd__decap_4
XFILLER_97_517 VPWR VGND VPWR VGND sky130_ef_sc_hd__decap_12
XFILLER_1_55 VGND VGND VPWR VPWR sky130_fd_sc_hd__fill_1
XFILLER_18_363 VGND VGND VPWR VPWR sky130_fd_sc_hd__fill_1
XFILLER_18_385 VGND VGND VPWR VPWR sky130_fd_sc_hd__fill_1
XFILLER_33_344 VGND VGND VPWR VPWR sky130_fd_sc_hd__decap_4
X_4761_ _4761_/CLK _4761_/D fanout144/X VGND VGND VPWR VPWR _4761_/Q sky130_fd_sc_hd__dfrtp_1
X_3712_ _3712_/A VGND VGND VPWR VPWR _3716_/A sky130_fd_sc_hd__inv_2
X_4692_ _4693_/CLK _4692_/D fanout156/X VGND VGND VPWR VPWR _4692_/Q sky130_fd_sc_hd__dfrtp_2
XTAP_TAPCELL_ROW_31_578 VGND VPWR sky130_fd_sc_hd__tapvpwrvgnd_1
X_3643_ _3644_/A _3644_/B _3644_/C VGND VGND VPWR VPWR _3645_/A sky130_fd_sc_hd__o21a_1
X_3574_ _3546_/A _3546_/B _3520_/X VGND VGND VPWR VPWR _3574_/X sky130_fd_sc_hd__a21o_1
X_2525_ _4469_/Q _2525_/B VGND VGND VPWR VPWR _2525_/X sky130_fd_sc_hd__or2_1
X_2456_ _2486_/A1 _2459_/B _2455_/X _2486_/B1 hold248/X VGND VGND VPWR VPWR _4448_/D
+ sky130_fd_sc_hd__a32o_1
Xhold29 hold29/A VGND VGND VPWR VPWR hold29/X sky130_fd_sc_hd__dlygate4sd3_1
Xhold18 hold18/A VGND VGND VPWR VPWR hold18/X sky130_fd_sc_hd__dlygate4sd3_1
X_2387_ hold231/X _2414_/A2 _2414_/B1 _4552_/Q VGND VGND VPWR VPWR _4402_/D sky130_fd_sc_hd__a22o_1
XFILLER_68_274 VGND VGND VPWR VPWR sky130_fd_sc_hd__decap_8
XFILLER_68_263 VGND VGND VPWR VPWR sky130_fd_sc_hd__decap_6
X_4126_ hold151/X _4135_/A1 _4130_/S VGND VGND VPWR VPWR _4656_/D sky130_fd_sc_hd__mux2_1
XFILLER_29_617 VPWR VGND VPWR VGND sky130_ef_sc_hd__decap_12
XFILLER_83_233 VGND VGND VPWR VPWR sky130_fd_sc_hd__fill_2
XFILLER_28_138 VGND VGND VPWR VPWR sky130_fd_sc_hd__fill_2
XFILLER_83_244 VGND VGND VPWR VPWR sky130_fd_sc_hd__fill_1
XFILLER_71_406 VGND VGND VPWR VPWR sky130_fd_sc_hd__decap_8
XTAP_TAPCELL_ROW_67_965 VGND VPWR sky130_fd_sc_hd__tapvpwrvgnd_1
X_4057_ _4138_/A1 hold197/X _4058_/S VGND VGND VPWR VPWR _4595_/D sky130_fd_sc_hd__mux2_1
XTAP_TAPCELL_ROW_39_656 VGND VPWR sky130_fd_sc_hd__tapvpwrvgnd_1
XFILLER_83_277 VGND VGND VPWR VPWR sky130_fd_sc_hd__decap_3
XFILLER_36_171 VGND VGND VPWR VPWR sky130_fd_sc_hd__decap_8
XFILLER_45_39 VPWR VGND VPWR VGND sky130_ef_sc_hd__decap_12
X_3008_ _3008_/A _3008_/B VGND VGND VPWR VPWR _3008_/Y sky130_fd_sc_hd__nand2_1
XFILLER_61_27 VPWR VGND VPWR VGND sky130_ef_sc_hd__decap_12
XFILLER_10_53 VPWR VGND VPWR VGND sky130_ef_sc_hd__decap_12
XPHY_EDGE_ROW_5_Left_113 VGND VGND VPWR VPWR sky130_fd_sc_hd__decap_3
XFILLER_79_517 VPWR VGND VPWR VGND sky130_ef_sc_hd__decap_12
XFILLER_87_561 VPWR VGND VPWR VGND sky130_ef_sc_hd__decap_12
XFILLER_101_393 VPWR VGND VPWR VGND sky130_ef_sc_hd__decap_12
XFILLER_19_51 VGND VGND VPWR VPWR sky130_fd_sc_hd__decap_4
XFILLER_19_138 VGND VGND VPWR VPWR sky130_fd_sc_hd__fill_1
XFILLER_35_94 VGND VGND VPWR VPWR sky130_fd_sc_hd__fill_1
XFILLER_42_141 VGND VGND VPWR VPWR sky130_fd_sc_hd__decap_6
XFILLER_42_174 VGND VGND VPWR VPWR sky130_fd_sc_hd__fill_1
XTAP_TAPCELL_ROW_90_1227 VGND VPWR sky130_fd_sc_hd__tapvpwrvgnd_1
X_2310_ _2311_/A _2310_/B _2310_/C VGND VGND VPWR VPWR _2313_/B sky130_fd_sc_hd__and3b_1
X_3290_ _3304_/B _3290_/B VGND VGND VPWR VPWR _3294_/A sky130_fd_sc_hd__nand2_1
X_2241_ _4554_/Q _2241_/B VGND VGND VPWR VPWR _2328_/B sky130_fd_sc_hd__nor2_1
XFILLER_65_200 VGND VGND VPWR VPWR sky130_fd_sc_hd__fill_1
XFILLER_18_3 VPWR VGND VPWR VGND sky130_ef_sc_hd__decap_12
XFILLER_93_553 VGND VGND VPWR VPWR sky130_fd_sc_hd__decap_6
XPHY_EDGE_ROW_69_Left_177 VGND VGND VPWR VPWR sky130_fd_sc_hd__decap_3
XTAP_TAPCELL_ROW_0_218 VGND VPWR sky130_fd_sc_hd__tapvpwrvgnd_1
XFILLER_93_597 VPWR VGND VPWR VGND sky130_ef_sc_hd__decap_12
XTAP_TAPCELL_ROW_64_935 VGND VPWR sky130_fd_sc_hd__tapvpwrvgnd_1
XTAP_TAPCELL_ROW_0_229 VGND VPWR sky130_fd_sc_hd__tapvpwrvgnd_1
XFILLER_25_108 VGND VGND VPWR VPWR sky130_fd_sc_hd__decap_4
XTAP_TAPCELL_ROW_36_626 VGND VPWR sky130_fd_sc_hd__tapvpwrvgnd_1
XFILLER_61_472 VPWR VGND VPWR VGND sky130_ef_sc_hd__decap_12
X_4744_ clkload7/A _4744_/D fanout127/X VGND VGND VPWR VPWR _4744_/Q sky130_fd_sc_hd__dfrtp_4
XPHY_EDGE_ROW_78_Left_186 VGND VGND VPWR VPWR sky130_fd_sc_hd__decap_3
X_4675_ _4756_/CLK _4675_/D fanout135/X VGND VGND VPWR VPWR _4675_/Q sky130_fd_sc_hd__dfrtp_1
X_3626_ _3626_/A _3626_/B VGND VGND VPWR VPWR _3627_/B sky130_fd_sc_hd__nand2_1
XTAP_TAPCELL_ROW_8_318 VGND VPWR sky130_fd_sc_hd__tapvpwrvgnd_1
X_3557_ _3676_/A _3558_/B _3558_/C VGND VGND VPWR VPWR _3628_/A sky130_fd_sc_hd__and3_1
X_2508_ _2511_/B VGND VGND VPWR VPWR _2508_/Y sky130_fd_sc_hd__inv_2
X_3488_ _4532_/Q _3489_/B VGND VGND VPWR VPWR _3488_/Y sky130_fd_sc_hd__nand2_1
XFILLER_69_561 VPWR VGND VPWR VGND sky130_ef_sc_hd__decap_12
X_2439_ _2486_/A1 _2442_/B _2438_/Y _2486_/B1 hold113/X VGND VGND VPWR VPWR _4443_/D
+ sky130_fd_sc_hd__a32o_1
XPHY_EDGE_ROW_87_Left_195 VGND VGND VPWR VPWR sky130_fd_sc_hd__decap_3
XFILLER_84_531 VGND VGND VPWR VPWR sky130_fd_sc_hd__fill_1
XFILLER_56_27 VGND VGND VPWR VPWR sky130_fd_sc_hd__fill_1
XFILLER_56_222 VGND VGND VPWR VPWR sky130_fd_sc_hd__fill_1
X_4109_ hold132/X _4024_/X _4112_/S VGND VGND VPWR VPWR _4641_/D sky130_fd_sc_hd__mux2_1
XFILLER_56_244 VGND VGND VPWR VPWR sky130_fd_sc_hd__fill_2
XFILLER_56_266 VGND VGND VPWR VPWR sky130_fd_sc_hd__fill_1
XFILLER_72_15 VPWR VGND VPWR VGND sky130_ef_sc_hd__decap_12
XFILLER_71_236 VGND VGND VPWR VPWR sky130_fd_sc_hd__fill_2
XFILLER_71_225 VGND VGND VPWR VPWR sky130_fd_sc_hd__fill_2
XFILLER_24_141 VGND VGND VPWR VPWR sky130_fd_sc_hd__decap_3
XFILLER_24_152 VGND VGND VPWR VPWR sky130_fd_sc_hd__decap_6
XFILLER_52_483 VGND VGND VPWR VPWR sky130_fd_sc_hd__fill_1
XFILLER_8_307 VGND VGND VPWR VPWR sky130_fd_sc_hd__fill_1
XFILLER_4_502 VGND VGND VPWR VPWR sky130_fd_sc_hd__fill_1
XFILLER_4_557 VGND VGND VPWR VPWR sky130_fd_sc_hd__decap_4
XTAP_TAPCELL_ROW_76_1071 VGND VPWR sky130_fd_sc_hd__tapvpwrvgnd_1
XFILLER_4_579 VGND VGND VPWR VPWR sky130_fd_sc_hd__fill_1
XFILLER_79_369 VGND VGND VPWR VPWR sky130_fd_sc_hd__decap_6
XFILLER_75_553 VGND VGND VPWR VPWR sky130_fd_sc_hd__decap_6
XFILLER_90_501 VPWR VGND VPWR VGND sky130_ef_sc_hd__decap_12
XFILLER_75_597 VPWR VGND VPWR VGND sky130_ef_sc_hd__decap_12
XFILLER_90_545 VPWR VGND VPWR VGND sky130_ef_sc_hd__decap_12
XFILLER_62_247 VGND VGND VPWR VPWR sky130_fd_sc_hd__decap_4
XFILLER_90_589 VPWR VGND VPWR VGND sky130_ef_sc_hd__decap_12
XTAP_TAPCELL_ROW_61_905 VGND VPWR sky130_fd_sc_hd__tapvpwrvgnd_1
XFILLER_15_141 VGND VGND VPWR VPWR sky130_fd_sc_hd__decap_6
XFILLER_43_472 VGND VGND VPWR VPWR sky130_fd_sc_hd__fill_1
XTAP_TAPCELL_ROW_13_375 VGND VPWR sky130_fd_sc_hd__tapvpwrvgnd_1
XFILLER_30_166 VGND VGND VPWR VPWR sky130_fd_sc_hd__fill_1
XFILLER_30_188 VGND VGND VPWR VPWR sky130_fd_sc_hd__decap_4
X_2790_ _4747_/Q _2790_/B VGND VGND VPWR VPWR _2791_/B sky130_fd_sc_hd__nand2_1
XTAP_TAPCELL_ROW_41_684 VGND VPWR sky130_fd_sc_hd__tapvpwrvgnd_1
XFILLER_7_373 VGND VGND VPWR VPWR sky130_fd_sc_hd__fill_1
X_4460_ _4708_/CLK _4460_/D fanout164/X VGND VGND VPWR VPWR hold75/A sky130_fd_sc_hd__dfrtp_1
X_3411_ _3412_/A _3412_/B VGND VGND VPWR VPWR _3430_/A sky130_fd_sc_hd__nand2_1
X_4391_ _4481_/CLK _4391_/D fanout152/X VGND VGND VPWR VPWR hold32/A sky130_fd_sc_hd__dfrtp_1
XFILLER_98_601 VPWR VGND VPWR VGND sky130_ef_sc_hd__decap_12
X_3342_ _3343_/A _3343_/B VGND VGND VPWR VPWR _3374_/A sky130_fd_sc_hd__nand2b_1
XFILLER_97_111 VGND VGND VPWR VPWR sky130_fd_sc_hd__fill_1
X_3273_ _3293_/A _3273_/B VGND VGND VPWR VPWR _3274_/B sky130_fd_sc_hd__and2_1
X_2224_ _4622_/Q VGND VGND VPWR VPWR _2224_/Y sky130_fd_sc_hd__inv_2
XFILLER_66_531 VGND VGND VPWR VPWR sky130_fd_sc_hd__fill_1
XFILLER_93_361 VPWR VGND VPWR VGND sky130_ef_sc_hd__decap_12
XTAP_TAPCELL_ROW_49_773 VGND VPWR sky130_fd_sc_hd__tapvpwrvgnd_1
XFILLER_41_409 VPWR VGND VPWR VGND sky130_ef_sc_hd__decap_12
XFILLER_53_269 VGND VGND VPWR VPWR sky130_fd_sc_hd__decap_8
XFILLER_42_29 VPWR VGND VPWR VGND sky130_ef_sc_hd__decap_12
X_2988_ _3009_/A _2967_/B _3008_/A VGND VGND VPWR VPWR _2989_/B sky130_fd_sc_hd__o21ba_1
X_4727_ _4727_/CLK _4727_/D fanout156/X VGND VGND VPWR VPWR _4727_/Q sky130_fd_sc_hd__dfrtp_2
X_4658_ _4661_/CLK _4658_/D fanout121/X VGND VGND VPWR VPWR _4658_/Q sky130_fd_sc_hd__dfrtp_1
XFILLER_107_249 VGND VGND VPWR VPWR sky130_fd_sc_hd__decap_3
X_3609_ _3608_/B _3608_/C _4537_/Q VGND VGND VPWR VPWR _3610_/B sky130_fd_sc_hd__a21bo_1
X_4589_ _4656_/CLK _4589_/D fanout120/X VGND VGND VPWR VPWR _4589_/Q sky130_fd_sc_hd__dfrtp_1
XFILLER_107_33 VPWR VGND VPWR VGND sky130_ef_sc_hd__decap_12
XFILLER_1_538 VPWR VGND VPWR VGND sky130_ef_sc_hd__decap_12
XPHY_EDGE_ROW_95_Left_203 VGND VGND VPWR VPWR sky130_fd_sc_hd__decap_3
XFILLER_67_15 VPWR VGND VPWR VGND sky130_ef_sc_hd__decap_12
XFILLER_29_222 VGND VGND VPWR VPWR sky130_fd_sc_hd__fill_2
XFILLER_57_553 VGND VGND VPWR VPWR sky130_fd_sc_hd__decap_6
XFILLER_72_501 VPWR VGND VPWR VGND sky130_ef_sc_hd__decap_12
XFILLER_57_597 VPWR VGND VPWR VGND sky130_ef_sc_hd__decap_12
XFILLER_83_69 VPWR VGND VPWR VGND sky130_ef_sc_hd__decap_12
XFILLER_72_545 VPWR VGND VPWR VGND sky130_ef_sc_hd__decap_12
XFILLER_72_589 VPWR VGND VPWR VGND sky130_ef_sc_hd__decap_12
XFILLER_16_41 VPWR VGND VPWR VGND sky130_ef_sc_hd__decap_12
XFILLER_12_111 VGND VGND VPWR VPWR sky130_fd_sc_hd__decap_3
XPHY_EDGE_ROW_11_Right_11 VGND VGND VPWR VPWR sky130_fd_sc_hd__decap_3
XFILLER_16_85 VGND VGND VPWR VPWR sky130_fd_sc_hd__fill_2
XFILLER_16_96 VGND VGND VPWR VPWR sky130_fd_sc_hd__decap_8
XFILLER_8_115 VGND VGND VPWR VPWR sky130_fd_sc_hd__decap_4
XTAP_TAPCELL_ROW_10_345 VGND VPWR sky130_fd_sc_hd__tapvpwrvgnd_1
XFILLER_4_365 VGND VGND VPWR VPWR sky130_fd_sc_hd__fill_1
XPHY_EDGE_ROW_20_Right_20 VGND VGND VPWR VPWR sky130_fd_sc_hd__decap_3
XFILLER_95_615 VGND VGND VPWR VPWR sky130_fd_sc_hd__fill_1
XFILLER_79_177 VPWR VGND VPWR VGND sky130_ef_sc_hd__decap_12
XFILLER_48_531 VGND VGND VPWR VPWR sky130_fd_sc_hd__fill_1
XFILLER_57_81 VGND VGND VPWR VPWR sky130_fd_sc_hd__decap_8
XTAP_TAPCELL_ROW_18_434 VGND VPWR sky130_fd_sc_hd__tapvpwrvgnd_1
XFILLER_35_225 VPWR VGND VPWR VGND sky130_ef_sc_hd__decap_12
XTAP_TAPCELL_ROW_46_743 VGND VPWR sky130_fd_sc_hd__tapvpwrvgnd_1
X_3960_ _3984_/B _3960_/B VGND VGND VPWR VPWR _3962_/A sky130_fd_sc_hd__nor2_1
XFILLER_90_375 VGND VGND VPWR VPWR sky130_fd_sc_hd__decap_8
X_2911_ _2963_/A _2911_/B VGND VGND VPWR VPWR _2925_/A sky130_fd_sc_hd__xnor2_1
X_3891_ _3978_/A _3889_/X _3890_/Y _3979_/B2 hold28/A VGND VGND VPWR VPWR _4548_/D
+ sky130_fd_sc_hd__a32o_1
XFILLER_85_3 VPWR VGND VPWR VGND sky130_ef_sc_hd__decap_12
XFILLER_31_475 VGND VGND VPWR VPWR sky130_fd_sc_hd__decap_3
X_2842_ _2842_/A _2842_/B VGND VGND VPWR VPWR _2850_/A sky130_fd_sc_hd__xor2_1
X_2773_ _2728_/X _2772_/Y _2743_/B VGND VGND VPWR VPWR _2774_/B sky130_fd_sc_hd__a21oi_1
X_4512_ _4513_/CLK _4512_/D fanout145/X VGND VGND VPWR VPWR _4512_/Q sky130_fd_sc_hd__dfrtp_4
Xhold126 _4672_/Q VGND VGND VPWR VPWR hold126/X sky130_fd_sc_hd__dlygate4sd3_1
Xhold104 _4623_/Q VGND VGND VPWR VPWR hold104/X sky130_fd_sc_hd__dlygate4sd3_1
Xhold115 _4565_/Q VGND VGND VPWR VPWR hold115/X sky130_fd_sc_hd__dlygate4sd3_1
XTAP_TAPCELL_ROW_96_1288 VGND VPWR sky130_fd_sc_hd__tapvpwrvgnd_1
Xhold137 _4651_/Q VGND VGND VPWR VPWR hold137/X sky130_fd_sc_hd__dlygate4sd3_1
Xhold148 _4645_/Q VGND VGND VPWR VPWR hold148/X sky130_fd_sc_hd__dlygate4sd3_1
X_4443_ _4735_/CLK _4443_/D fanout148/X VGND VGND VPWR VPWR _4443_/Q sky130_fd_sc_hd__dfrtp_1
Xhold159 _4598_/Q VGND VGND VPWR VPWR hold159/X sky130_fd_sc_hd__dlygate4sd3_1
X_4374_ _4531_/CLK _4374_/D fanout150/X VGND VGND VPWR VPWR hold81/A sky130_fd_sc_hd__dfrtp_1
XFILLER_98_475 VGND VGND VPWR VPWR sky130_fd_sc_hd__fill_1
X_3325_ _3325_/A _3325_/B _3325_/C VGND VGND VPWR VPWR _3326_/B sky130_fd_sc_hd__nand3_1
X_3256_ hold290/X _4355_/A2 _3988_/A _4354_/B2 VGND VGND VPWR VPWR _4521_/D sky130_fd_sc_hd__a22o_1
XFILLER_85_125 VGND VGND VPWR VPWR sky130_fd_sc_hd__decap_8
XFILLER_100_469 VGND VGND VPWR VPWR sky130_fd_sc_hd__decap_6
X_2207_ _4709_/Q VGND VGND VPWR VPWR _4240_/A sky130_fd_sc_hd__inv_2
X_3187_ _4517_/Q _3189_/B VGND VGND VPWR VPWR _3187_/X sky130_fd_sc_hd__and2_1
XFILLER_66_361 VGND VGND VPWR VPWR sky130_fd_sc_hd__decap_3
XFILLER_81_331 VGND VGND VPWR VPWR sky130_fd_sc_hd__decap_4
XFILLER_26_236 VPWR VGND VPWR VGND sky130_ef_sc_hd__decap_12
XFILLER_54_545 VPWR VGND VPWR VGND sky130_ef_sc_hd__decap_12
XFILLER_54_589 VPWR VGND VPWR VGND sky130_ef_sc_hd__decap_12
XFILLER_41_217 VGND VGND VPWR VPWR sky130_fd_sc_hd__decap_6
XFILLER_53_39 VPWR VGND VPWR VGND sky130_ef_sc_hd__decap_12
XTAP_TAPCELL_ROW_105_1384 VGND VPWR sky130_fd_sc_hd__tapvpwrvgnd_1
XFILLER_34_291 VGND VGND VPWR VPWR sky130_fd_sc_hd__decap_4
XTAP_TAPCELL_ROW_73_1030 VGND VPWR sky130_fd_sc_hd__tapvpwrvgnd_1
XFILLER_1_313 VPWR VGND VPWR VGND sky130_ef_sc_hd__decap_12
XFILLER_77_615 VGND VGND VPWR VPWR sky130_fd_sc_hd__fill_1
XFILLER_89_497 VGND VGND VPWR VPWR sky130_fd_sc_hd__decap_6
XFILLER_64_309 VGND VGND VPWR VPWR sky130_fd_sc_hd__fill_1
XFILLER_72_320 VGND VGND VPWR VPWR sky130_fd_sc_hd__decap_6
XFILLER_17_225 VGND VGND VPWR VPWR sky130_fd_sc_hd__fill_2
XFILLER_27_51 VGND VGND VPWR VPWR sky130_fd_sc_hd__decap_4
XFILLER_32_239 VGND VGND VPWR VPWR sky130_fd_sc_hd__decap_4
XTAP_TAPCELL_ROW_43_702 VGND VPWR sky130_fd_sc_hd__tapvpwrvgnd_1
XFILLER_13_442 VGND VGND VPWR VPWR sky130_fd_sc_hd__decap_6
XFILLER_9_413 VGND VGND VPWR VPWR sky130_fd_sc_hd__decap_3
XFILLER_40_250 VGND VGND VPWR VPWR sky130_fd_sc_hd__fill_2
XTAP_TAPCELL_ROW_23_481 VGND VPWR sky130_fd_sc_hd__tapvpwrvgnd_1
XTAP_TAPCELL_ROW_51_790 VGND VPWR sky130_fd_sc_hd__tapvpwrvgnd_1
XFILLER_99_217 VGND VGND VPWR VPWR sky130_fd_sc_hd__decap_6
XFILLER_4_77 VGND VGND VPWR VPWR sky130_fd_sc_hd__decap_6
X_3110_ _4581_/Q hold48/A _4645_/Q hold83/A _4324_/S _3174_/S1 VGND VGND VPWR VPWR
+ _3112_/B sky130_fd_sc_hd__mux4_1
X_4090_ hold88/X _4732_/Q _4093_/S VGND VGND VPWR VPWR _4625_/D sky130_fd_sc_hd__mux2_1
XFILLER_0_390 VGND VGND VPWR VPWR sky130_fd_sc_hd__fill_2
XFILLER_83_629 VGND VGND VPWR VPWR sky130_fd_sc_hd__decap_8
X_3041_ _3061_/B _3041_/B VGND VGND VPWR VPWR _3050_/A sky130_fd_sc_hd__xor2_4
XFILLER_82_139 VGND VGND VPWR VPWR sky130_fd_sc_hd__fill_1
XFILLER_36_523 VGND VGND VPWR VPWR sky130_fd_sc_hd__fill_1
XFILLER_23_206 VGND VGND VPWR VPWR sky130_fd_sc_hd__fill_1
X_3943_ _3943_/A _3943_/B _3943_/C VGND VGND VPWR VPWR _3945_/A sky130_fd_sc_hd__and3_1
X_3874_ _4647_/Q _4583_/Q hold70/A hold38/A _3915_/S0 _3915_/S1 VGND VGND VPWR VPWR
+ _3876_/B sky130_fd_sc_hd__mux4_1
XTAP_TAPCELL_ROW_98_1306 VGND VPWR sky130_fd_sc_hd__tapvpwrvgnd_1
Xclkbuf_3_2__f_clk clkbuf_0_clk/X VGND VGND VPWR VPWR clkload2/A sky130_fd_sc_hd__clkbuf_16
X_2825_ _2825_/A _2825_/B VGND VGND VPWR VPWR _2827_/B sky130_fd_sc_hd__xnor2_1
X_2756_ _2734_/A _2757_/A _2758_/B _2758_/A VGND VGND VPWR VPWR _3348_/B sky130_fd_sc_hd__a211o_1
XFILLER_105_517 VPWR VGND VPWR VGND sky130_ef_sc_hd__decap_12
X_2687_ _2667_/A _2666_/B _2664_/X VGND VGND VPWR VPWR _2688_/B sky130_fd_sc_hd__a21o_1
X_4426_ _4513_/CLK _4426_/D fanout169/X VGND VGND VPWR VPWR _4426_/Q sky130_fd_sc_hd__dfrtp_1
XFILLER_59_615 VGND VGND VPWR VPWR sky130_fd_sc_hd__fill_1
X_4357_ _4724_/CLK hold7/X fanout160/X VGND VGND VPWR VPWR hold6/A sky130_fd_sc_hd__dfrtp_1
XFILLER_100_233 VPWR VGND VPWR VGND sky130_ef_sc_hd__decap_12
XFILLER_86_456 VPWR VGND VPWR VGND sky130_ef_sc_hd__decap_12
X_4288_ uo_out[2] _4287_/Y _4323_/S VGND VGND VPWR VPWR _4721_/D sky130_fd_sc_hd__mux2_1
X_3308_ _3396_/A _3495_/A VGND VGND VPWR VPWR _3310_/A sky130_fd_sc_hd__xor2_1
XFILLER_100_277 VPWR VGND VPWR VGND sky130_ef_sc_hd__decap_12
X_3239_ _3239_/A _3239_/B VGND VGND VPWR VPWR _3240_/B sky130_fd_sc_hd__xnor2_1
XFILLER_86_489 VPWR VGND VPWR VGND sky130_ef_sc_hd__decap_12
XFILLER_27_501 VGND VGND VPWR VPWR sky130_fd_sc_hd__decap_3
XTAP_TAPCELL_ROW_107_1424 VGND VPWR sky130_fd_sc_hd__tapvpwrvgnd_1
XTAP_TAPCELL_ROW_107_1413 VGND VPWR sky130_fd_sc_hd__tapvpwrvgnd_1
XFILLER_64_27 VGND VGND VPWR VPWR sky130_fd_sc_hd__fill_1
Xfanout21 _3522_/B VGND VGND VPWR VPWR _3915_/S1 sky130_fd_sc_hd__clkbuf_4
XFILLER_80_15 VPWR VGND VPWR VGND sky130_ef_sc_hd__decap_12
Xfanout43 _2347_/X VGND VGND VPWR VPWR _4149_/B sky130_fd_sc_hd__clkbuf_4
Xfanout54 _4018_/X VGND VGND VPWR VPWR _4133_/A1 sky130_fd_sc_hd__clkbuf_4
Xfanout32 _4256_/A1 VGND VGND VPWR VPWR _2395_/B1 sky130_fd_sc_hd__buf_2
XFILLER_22_250 VGND VGND VPWR VPWR sky130_fd_sc_hd__fill_2
Xfanout65 _4262_/A VGND VGND VPWR VPWR _2414_/A2 sky130_fd_sc_hd__buf_2
Xfanout76 _4355_/B2 VGND VGND VPWR VPWR _4354_/B2 sky130_fd_sc_hd__clkbuf_4
Xfanout98 _4737_/Q VGND VGND VPWR VPWR _2837_/S1 sky130_fd_sc_hd__buf_2
Xfanout87 _3081_/A2 VGND VGND VPWR VPWR _4345_/A2 sky130_fd_sc_hd__clkbuf_4
XTAP_TAPCELL_ROW_20_451 VGND VPWR sky130_fd_sc_hd__tapvpwrvgnd_1
XFILLER_89_57 VPWR VGND VPWR VGND sky130_ef_sc_hd__decap_12
XFILLER_96_209 VPWR VGND VPWR VGND sky130_ef_sc_hd__decap_12
XFILLER_77_445 VGND VGND VPWR VPWR sky130_fd_sc_hd__decap_3
XFILLER_65_629 VGND VGND VPWR VPWR sky130_fd_sc_hd__decap_8
XFILLER_49_169 VGND VGND VPWR VPWR sky130_fd_sc_hd__decap_6
XFILLER_38_83 VGND VGND VPWR VPWR sky130_fd_sc_hd__fill_1
XTAP_TAPCELL_ROW_28_540 VGND VPWR sky130_fd_sc_hd__tapvpwrvgnd_1
XTAP_TAPCELL_ROW_82_1129 VGND VPWR sky130_fd_sc_hd__tapvpwrvgnd_1
XFILLER_60_301 VGND VGND VPWR VPWR sky130_fd_sc_hd__decap_6
XFILLER_72_194 VGND VGND VPWR VPWR sky130_fd_sc_hd__fill_2
XFILLER_13_250 VGND VGND VPWR VPWR sky130_fd_sc_hd__decap_6
XFILLER_41_570 VGND VGND VPWR VPWR sky130_fd_sc_hd__decap_6
XFILLER_41_592 VGND VGND VPWR VPWR sky130_fd_sc_hd__decap_6
XFILLER_9_276 VGND VGND VPWR VPWR sky130_fd_sc_hd__decap_4
Xclkload24 _4764_/CLK VGND VGND VPWR VPWR clkload24/Y sky130_fd_sc_hd__bufinv_16
X_2610_ _4530_/Q _4525_/Q VGND VGND VPWR VPWR _2611_/B sky130_fd_sc_hd__or2_1
Xclkload35 _4495_/CLK VGND VGND VPWR VPWR clkload35/Y sky130_fd_sc_hd__inv_8
XPHY_EDGE_ROW_41_Left_149 VGND VGND VPWR VPWR sky130_fd_sc_hd__decap_3
Xclkload13 _4750_/CLK VGND VGND VPWR VPWR clkload13/X sky130_fd_sc_hd__clkbuf_4
X_3590_ _4536_/Q _3748_/B2 _3588_/X _3589_/Y VGND VGND VPWR VPWR _4536_/D sky130_fd_sc_hd__a22o_1
Xclkload46 _4552_/CLK VGND VGND VPWR VPWR clkload46/Y sky130_fd_sc_hd__clkinvlp_4
X_2541_ _4474_/Q _4473_/Q _4475_/Q VGND VGND VPWR VPWR _2541_/X sky130_fd_sc_hd__a21o_1
XTAP_TAPCELL_ROW_93_1258 VGND VPWR sky130_fd_sc_hd__tapvpwrvgnd_1
X_2472_ _4453_/Q _2468_/A _2482_/B1 VGND VGND VPWR VPWR _2472_/Y sky130_fd_sc_hd__o21ai_1
XFILLER_87_209 VPWR VGND VPWR VGND sky130_ef_sc_hd__decap_12
X_4211_ _4701_/Q _4212_/B VGND VGND VPWR VPWR _4211_/X sky130_fd_sc_hd__or2_1
XFILLER_48_3 VPWR VGND VPWR VGND sky130_ef_sc_hd__decap_12
XFILLER_68_401 VGND VGND VPWR VPWR sky130_fd_sc_hd__decap_8
X_4142_ hold123/X _4018_/X _4148_/S VGND VGND VPWR VPWR _4670_/D sky130_fd_sc_hd__mux2_1
XFILLER_68_489 VPWR VGND VPWR VGND sky130_ef_sc_hd__decap_12
X_4073_ _4136_/A1 hold182/X _4076_/S VGND VGND VPWR VPWR _4609_/D sky130_fd_sc_hd__mux2_1
XPHY_EDGE_ROW_50_Left_158 VGND VGND VPWR VPWR sky130_fd_sc_hd__decap_3
X_3024_ _4510_/Q _3025_/B VGND VGND VPWR VPWR _3054_/A sky130_fd_sc_hd__nand2_1
XFILLER_51_312 VGND VGND VPWR VPWR sky130_fd_sc_hd__decap_4
XTAP_TAPCELL_ROW_102_1354 VGND VPWR sky130_fd_sc_hd__tapvpwrvgnd_1
X_3926_ _3926_/A _3926_/B VGND VGND VPWR VPWR _3928_/B sky130_fd_sc_hd__xnor2_1
X_3857_ _3878_/B _3857_/B VGND VGND VPWR VPWR _3864_/A sky130_fd_sc_hd__or2_1
Xclkload7 clkload7/A VGND VGND VPWR VPWR clkload7/Y sky130_fd_sc_hd__clkinv_2
XFILLER_50_29 VPWR VGND VPWR VGND sky130_ef_sc_hd__decap_12
X_3788_ _3788_/A _3788_/B VGND VGND VPWR VPWR _3791_/B sky130_fd_sc_hd__xnor2_2
X_2808_ _2808_/A _2808_/B _2808_/C VGND VGND VPWR VPWR _2808_/X sky130_fd_sc_hd__or3_1
X_2739_ _3382_/A _4536_/Q VGND VGND VPWR VPWR _2741_/B sky130_fd_sc_hd__or2_1
XFILLER_59_27 VPWR VGND VPWR VGND sky130_ef_sc_hd__decap_12
XTAP_TAPCELL_ROW_70_1000 VGND VPWR sky130_fd_sc_hd__tapvpwrvgnd_1
X_4409_ _4532_/CLK _4409_/D fanout154/X VGND VGND VPWR VPWR _4409_/Q sky130_fd_sc_hd__dfrtp_1
XFILLER_101_553 VGND VGND VPWR VPWR sky130_fd_sc_hd__decap_6
XFILLER_75_15 VPWR VGND VPWR VGND sky130_ef_sc_hd__decap_12
XFILLER_47_629 VGND VGND VPWR VPWR sky130_fd_sc_hd__decap_8
XFILLER_101_597 VPWR VGND VPWR VGND sky130_ef_sc_hd__decap_12
XFILLER_74_459 VPWR VGND VPWR VGND sky130_ef_sc_hd__decap_12
XFILLER_61_109 VGND VGND VPWR VPWR sky130_fd_sc_hd__decap_3
XFILLER_27_386 VGND VGND VPWR VPWR sky130_fd_sc_hd__decap_6
XTAP_TAPCELL_ROW_25_510 VGND VPWR sky130_fd_sc_hd__tapvpwrvgnd_1
XFILLER_91_69 VPWR VGND VPWR VGND sky130_ef_sc_hd__decap_12
XFILLER_24_41 VPWR VGND VPWR VGND sky130_ef_sc_hd__decap_12
XFILLER_30_529 VGND VGND VPWR VPWR sky130_fd_sc_hd__decap_3
XFILLER_24_85 VPWR VGND VPWR VGND sky130_ef_sc_hd__decap_12
XFILLER_10_231 VGND VGND VPWR VPWR sky130_fd_sc_hd__decap_6
XFILLER_6_202 VGND VGND VPWR VPWR sky130_fd_sc_hd__fill_1
XFILLER_40_73 VGND VGND VPWR VPWR sky130_fd_sc_hd__decap_3
XFILLER_97_529 VPWR VGND VPWR VGND sky130_ef_sc_hd__decap_12
XFILLER_38_618 VGND VGND VPWR VPWR sky130_fd_sc_hd__fill_1
XTAP_TAPCELL_ROW_5_290 VGND VPWR sky130_fd_sc_hd__tapvpwrvgnd_1
XFILLER_37_117 VGND VGND VPWR VPWR sky130_fd_sc_hd__fill_1
XFILLER_92_245 VGND VGND VPWR VPWR sky130_fd_sc_hd__fill_2
XFILLER_33_334 VGND VGND VPWR VPWR sky130_fd_sc_hd__fill_2
XFILLER_45_194 VGND VGND VPWR VPWR sky130_fd_sc_hd__decap_6
X_4760_ _4761_/CLK _4760_/D fanout140/X VGND VGND VPWR VPWR _4760_/Q sky130_fd_sc_hd__dfrtp_1
XFILLER_14_570 VGND VGND VPWR VPWR sky130_fd_sc_hd__decap_6
XFILLER_60_197 VGND VGND VPWR VPWR sky130_fd_sc_hd__decap_4
X_3711_ _4541_/Q _3713_/B VGND VGND VPWR VPWR _3712_/A sky130_fd_sc_hd__or2_1
X_4691_ _4693_/CLK _4691_/D fanout156/X VGND VGND VPWR VPWR _4691_/Q sky130_fd_sc_hd__dfrtp_1
XTAP_TAPCELL_ROW_31_568 VGND VPWR sky130_fd_sc_hd__tapvpwrvgnd_1
X_3642_ _4538_/Q _3642_/B VGND VGND VPWR VPWR _3644_/C sky130_fd_sc_hd__xnor2_1
X_3573_ _3573_/A _3573_/B VGND VGND VPWR VPWR _3578_/A sky130_fd_sc_hd__and2_1
XPHY_EDGE_ROW_49_Right_49 VGND VGND VPWR VPWR sky130_fd_sc_hd__decap_3
X_2524_ _4469_/Q _2525_/B VGND VGND VPWR VPWR _2529_/B sky130_fd_sc_hd__nand2_1
X_2455_ _4448_/Q _2455_/B VGND VGND VPWR VPWR _2455_/X sky130_fd_sc_hd__or2_1
X_2386_ hold207/X _2414_/A2 _2414_/B1 _4551_/Q VGND VGND VPWR VPWR _4401_/D sky130_fd_sc_hd__a22o_1
Xhold19 hold19/A VGND VGND VPWR VPWR hold19/X sky130_fd_sc_hd__dlygate4sd3_1
XFILLER_68_253 VGND VGND VPWR VPWR sky130_fd_sc_hd__decap_3
X_4125_ hold86/X _4134_/A1 _4130_/S VGND VGND VPWR VPWR _4655_/D sky130_fd_sc_hd__mux2_1
XFILLER_29_629 VGND VGND VPWR VPWR sky130_fd_sc_hd__decap_4
XTAP_TAPCELL_ROW_67_966 VGND VPWR sky130_fd_sc_hd__tapvpwrvgnd_1
X_4056_ _4137_/A1 hold158/X _4058_/S VGND VGND VPWR VPWR _4594_/D sky130_fd_sc_hd__mux2_1
XTAP_TAPCELL_ROW_39_657 VGND VPWR sky130_fd_sc_hd__tapvpwrvgnd_1
XPHY_EDGE_ROW_58_Right_58 VGND VGND VPWR VPWR sky130_fd_sc_hd__decap_3
X_3007_ _3007_/A _3007_/B VGND VGND VPWR VPWR _3061_/A sky130_fd_sc_hd__nand2_1
XFILLER_52_610 VPWR VGND VPWR VGND sky130_ef_sc_hd__decap_12
XFILLER_24_323 VGND VGND VPWR VPWR sky130_fd_sc_hd__fill_1
XFILLER_101_57 VPWR VGND VPWR VGND sky130_ef_sc_hd__decap_12
XFILLER_61_39 VPWR VGND VPWR VGND sky130_ef_sc_hd__decap_12
XFILLER_12_529 VGND VGND VPWR VPWR sky130_fd_sc_hd__decap_3
X_3909_ _3886_/Y _3890_/Y _3931_/B VGND VGND VPWR VPWR _3909_/Y sky130_fd_sc_hd__a21oi_1
XFILLER_106_601 VPWR VGND VPWR VGND sky130_ef_sc_hd__decap_12
XPHY_EDGE_ROW_67_Right_67 VGND VGND VPWR VPWR sky130_fd_sc_hd__decap_3
XFILLER_105_111 VGND VGND VPWR VPWR sky130_fd_sc_hd__fill_1
XFILLER_79_529 VPWR VGND VPWR VGND sky130_ef_sc_hd__decap_12
XFILLER_10_65 VPWR VGND VPWR VGND sky130_ef_sc_hd__decap_12
XFILLER_87_573 VPWR VGND VPWR VGND sky130_ef_sc_hd__decap_12
XFILLER_101_361 VPWR VGND VPWR VGND sky130_ef_sc_hd__decap_12
XPHY_EDGE_ROW_76_Right_76 VGND VGND VPWR VPWR sky130_fd_sc_hd__decap_3
XFILLER_74_201 VPWR VGND VPWR VGND sky130_ef_sc_hd__decap_12
XFILLER_59_297 VGND VGND VPWR VPWR sky130_fd_sc_hd__decap_8
XPHY_EDGE_ROW_106_Left_214 VGND VGND VPWR VPWR sky130_fd_sc_hd__decap_3
XFILLER_35_51 VGND VGND VPWR VPWR sky130_fd_sc_hd__decap_4
XFILLER_55_481 VPWR VGND VPWR VGND sky130_ef_sc_hd__decap_12
XFILLER_70_473 VGND VGND VPWR VPWR sky130_fd_sc_hd__decap_3
XFILLER_42_197 VGND VGND VPWR VPWR sky130_fd_sc_hd__fill_1
XPHY_EDGE_ROW_85_Right_85 VGND VGND VPWR VPWR sky130_fd_sc_hd__decap_3
XFILLER_51_94 VGND VGND VPWR VPWR sky130_fd_sc_hd__decap_4
XTAP_TAPCELL_ROW_90_1217 VGND VPWR sky130_fd_sc_hd__tapvpwrvgnd_1
XFILLER_97_337 VPWR VGND VPWR VGND sky130_ef_sc_hd__decap_12
XFILLER_2_260 VPWR VGND VPWR VGND sky130_ef_sc_hd__decap_12
XFILLER_2_282 VGND VGND VPWR VPWR sky130_fd_sc_hd__decap_8
X_2240_ hold6/X _2176_/Y _4370_/D VGND VGND VPWR VPWR hold7/A sky130_fd_sc_hd__a21o_1
XPHY_EDGE_ROW_94_Right_94 VGND VGND VPWR VPWR sky130_fd_sc_hd__decap_3
XFILLER_65_223 VGND VGND VPWR VPWR sky130_fd_sc_hd__fill_1
XFILLER_38_459 VGND VGND VPWR VPWR sky130_fd_sc_hd__fill_1
XFILLER_80_215 VPWR VGND VPWR VGND sky130_ef_sc_hd__decap_12
XTAP_TAPCELL_ROW_64_936 VGND VPWR sky130_fd_sc_hd__tapvpwrvgnd_1
XTAP_TAPCELL_ROW_0_219 VGND VPWR sky130_fd_sc_hd__tapvpwrvgnd_1
XTAP_TAPCELL_ROW_36_627 VGND VPWR sky130_fd_sc_hd__tapvpwrvgnd_1
XFILLER_46_470 VGND VGND VPWR VPWR sky130_fd_sc_hd__decap_6
XFILLER_53_429 VGND VGND VPWR VPWR sky130_fd_sc_hd__decap_8
XFILLER_18_194 VGND VGND VPWR VPWR sky130_fd_sc_hd__fill_2
XFILLER_61_484 VPWR VGND VPWR VGND sky130_ef_sc_hd__decap_12
X_4743_ clkload9/A _4743_/D fanout129/X VGND VGND VPWR VPWR _4743_/Q sky130_fd_sc_hd__dfrtp_4
X_4674_ _4676_/CLK _4674_/D fanout134/X VGND VGND VPWR VPWR _4674_/Q sky130_fd_sc_hd__dfrtp_1
X_3625_ _3577_/A _3577_/B _3623_/X _3622_/X _3626_/A VGND VGND VPWR VPWR _3651_/B
+ sky130_fd_sc_hd__a311o_1
X_3556_ _3556_/A _3556_/B _3556_/C VGND VGND VPWR VPWR _3558_/C sky130_fd_sc_hd__nand3_1
XFILLER_103_615 VGND VGND VPWR VPWR sky130_fd_sc_hd__fill_1
XTAP_TAPCELL_ROW_8_319 VGND VPWR sky130_fd_sc_hd__tapvpwrvgnd_1
X_2507_ _2509_/A _2509_/B VGND VGND VPWR VPWR _2511_/B sky130_fd_sc_hd__nor2_1
X_3487_ _3487_/A _3487_/B VGND VGND VPWR VPWR _3489_/B sky130_fd_sc_hd__xnor2_2
X_2438_ _2438_/A _2438_/B VGND VGND VPWR VPWR _2438_/Y sky130_fd_sc_hd__nand2_1
XFILLER_69_573 VPWR VGND VPWR VGND sky130_ef_sc_hd__decap_12
XFILLER_29_415 VGND VGND VPWR VPWR sky130_fd_sc_hd__decap_8
X_2369_ _4384_/Q _2379_/A2 _2379_/B1 hold2/X VGND VGND VPWR VPWR hold3/A sky130_fd_sc_hd__a22o_1
X_4108_ hold121/X _4022_/X _4112_/S VGND VGND VPWR VPWR _4640_/D sky130_fd_sc_hd__mux2_1
XFILLER_84_587 VGND VGND VPWR VPWR sky130_fd_sc_hd__fill_1
X_4039_ _4138_/A1 hold184/X _4040_/S VGND VGND VPWR VPWR _4579_/D sky130_fd_sc_hd__mux2_1
XFILLER_44_418 VGND VGND VPWR VPWR sky130_fd_sc_hd__fill_2
XFILLER_37_492 VGND VGND VPWR VPWR sky130_fd_sc_hd__fill_2
XFILLER_72_27 VGND VGND VPWR VPWR sky130_fd_sc_hd__fill_1
XFILLER_24_164 VGND VGND VPWR VPWR sky130_fd_sc_hd__decap_8
XFILLER_12_348 VGND VGND VPWR VPWR sky130_fd_sc_hd__fill_1
XFILLER_24_197 VPWR VGND VPWR VGND sky130_ef_sc_hd__decap_12
XFILLER_106_475 VGND VGND VPWR VPWR sky130_fd_sc_hd__fill_1
XTAP_TAPCELL_ROW_76_1072 VGND VPWR sky130_fd_sc_hd__tapvpwrvgnd_1
XFILLER_97_57 VPWR VGND VPWR VGND sky130_ef_sc_hd__decap_12
XFILLER_90_513 VPWR VGND VPWR VGND sky130_ef_sc_hd__decap_12
XFILLER_90_557 VPWR VGND VPWR VGND sky130_ef_sc_hd__decap_12
XTAP_TAPCELL_ROW_87_1190 VGND VPWR sky130_fd_sc_hd__tapvpwrvgnd_1
XTAP_TAPCELL_ROW_61_906 VGND VPWR sky130_fd_sc_hd__tapvpwrvgnd_1
XTAP_TAPCELL_ROW_13_376 VGND VPWR sky130_fd_sc_hd__tapvpwrvgnd_1
XTAP_TAPCELL_ROW_41_685 VGND VPWR sky130_fd_sc_hd__tapvpwrvgnd_1
XFILLER_7_55 VGND VGND VPWR VPWR sky130_fd_sc_hd__fill_1
X_3410_ hold90/A _4564_/Q _4660_/Q _4596_/Q _3569_/S0 _3283_/S VGND VGND VPWR VPWR
+ _3412_/B sky130_fd_sc_hd__mux4_1
X_4390_ _4532_/CLK _4390_/D fanout153/X VGND VGND VPWR VPWR hold34/A sky130_fd_sc_hd__dfrtp_1
XFILLER_98_613 VPWR VGND VPWR VGND sky130_ef_sc_hd__decap_12
X_3341_ hold88/A hold87/A hold99/A _4593_/Q _3569_/S0 _3283_/S VGND VGND VPWR VPWR
+ _3343_/B sky130_fd_sc_hd__mux4_1
XFILLER_97_167 VGND VGND VPWR VPWR sky130_fd_sc_hd__fill_1
X_3272_ _3272_/A _3451_/A VGND VGND VPWR VPWR _3273_/B sky130_fd_sc_hd__or2_1
XFILLER_30_3 VPWR VGND VPWR VGND sky130_ef_sc_hd__decap_12
X_2223_ _4590_/Q VGND VGND VPWR VPWR _2223_/Y sky130_fd_sc_hd__inv_2
XFILLER_38_223 VGND VGND VPWR VPWR sky130_fd_sc_hd__decap_8
XFILLER_93_373 VGND VGND VPWR VPWR sky130_fd_sc_hd__decap_3
XFILLER_66_587 VGND VGND VPWR VPWR sky130_fd_sc_hd__fill_1
XTAP_TAPCELL_ROW_49_774 VGND VPWR sky130_fd_sc_hd__tapvpwrvgnd_1
XFILLER_19_470 VPWR VGND VPWR VGND sky130_ef_sc_hd__decap_12
XFILLER_21_101 VGND VGND VPWR VPWR sky130_fd_sc_hd__fill_1
XFILLER_21_167 VGND VGND VPWR VPWR sky130_fd_sc_hd__fill_1
X_2987_ _3008_/B _2987_/B VGND VGND VPWR VPWR _3009_/B sky130_fd_sc_hd__nand2_1
X_4726_ _4726_/CLK _4726_/D fanout160/X VGND VGND VPWR VPWR uo_out[7] sky130_fd_sc_hd__dfrtp_4
X_4657_ _4661_/CLK _4657_/D fanout123/X VGND VGND VPWR VPWR hold99/A sky130_fd_sc_hd__dfrtp_1
X_3608_ _4537_/Q _3608_/B _3608_/C VGND VGND VPWR VPWR _3610_/A sky130_fd_sc_hd__nand3b_1
X_4588_ _4764_/CLK _4588_/D fanout140/X VGND VGND VPWR VPWR _4588_/Q sky130_fd_sc_hd__dfrtp_1
XFILLER_107_45 VGND VGND VPWR VPWR sky130_fd_sc_hd__decap_8
X_3539_ _3536_/A _2558_/B _3538_/X _3554_/B2 VGND VGND VPWR VPWR _4534_/D sky130_fd_sc_hd__a22o_1
XFILLER_88_167 VGND VGND VPWR VPWR sky130_fd_sc_hd__decap_8
XFILLER_67_27 VPWR VGND VPWR VGND sky130_ef_sc_hd__decap_12
XFILLER_84_351 VGND VGND VPWR VPWR sky130_fd_sc_hd__fill_2
XFILLER_83_15 VPWR VGND VPWR VGND sky130_ef_sc_hd__decap_12
XFILLER_72_513 VPWR VGND VPWR VGND sky130_ef_sc_hd__decap_12
XFILLER_72_557 VPWR VGND VPWR VGND sky130_ef_sc_hd__decap_12
XFILLER_16_53 VPWR VGND VPWR VGND sky130_ef_sc_hd__decap_12
XFILLER_40_410 VGND VGND VPWR VPWR sky130_fd_sc_hd__fill_1
XFILLER_9_617 VPWR VGND VPWR VGND sky130_ef_sc_hd__decap_12
XFILLER_40_465 VGND VGND VPWR VPWR sky130_fd_sc_hd__decap_8
XFILLER_8_149 VGND VGND VPWR VPWR sky130_fd_sc_hd__decap_4
XFILLER_32_41 VPWR VGND VPWR VGND sky130_ef_sc_hd__decap_12
XTAP_TAPCELL_ROW_10_346 VGND VPWR sky130_fd_sc_hd__tapvpwrvgnd_1
XFILLER_4_300 VGND VGND VPWR VPWR sky130_fd_sc_hd__decap_8
XFILLER_79_189 VGND VGND VPWR VPWR sky130_fd_sc_hd__decap_3
XFILLER_79_167 VGND VGND VPWR VPWR sky130_fd_sc_hd__fill_1
XFILLER_0_561 VPWR VGND VPWR VGND sky130_ef_sc_hd__decap_12
XFILLER_35_237 VGND VGND VPWR VPWR sky130_fd_sc_hd__decap_4
XTAP_TAPCELL_ROW_46_733 VGND VPWR sky130_fd_sc_hd__tapvpwrvgnd_1
XFILLER_90_365 VGND VGND VPWR VPWR sky130_fd_sc_hd__decap_4
XTAP_TAPCELL_ROW_18_435 VGND VPWR sky130_fd_sc_hd__tapvpwrvgnd_1
X_2910_ _2813_/B _2813_/C _2908_/Y _2909_/X VGND VGND VPWR VPWR _2911_/B sky130_fd_sc_hd__a31o_1
X_3890_ _3889_/A _3889_/B _3889_/C VGND VGND VPWR VPWR _3890_/Y sky130_fd_sc_hd__o21ai_1
XFILLER_31_421 VGND VGND VPWR VPWR sky130_fd_sc_hd__decap_6
XFILLER_43_281 VPWR VGND VPWR VGND sky130_ef_sc_hd__decap_12
X_2841_ _2841_/A _2841_/B VGND VGND VPWR VPWR _2842_/B sky130_fd_sc_hd__nand2_1
XFILLER_78_3 VPWR VGND VPWR VGND sky130_ef_sc_hd__decap_12
X_2772_ _4530_/Q _2723_/B _2743_/A VGND VGND VPWR VPWR _2772_/Y sky130_fd_sc_hd__a21oi_1
XFILLER_31_498 VGND VGND VPWR VPWR sky130_fd_sc_hd__decap_6
X_4511_ _4513_/CLK _4511_/D fanout143/X VGND VGND VPWR VPWR _4511_/Q sky130_fd_sc_hd__dfrtp_4
Xhold105 _4650_/Q VGND VGND VPWR VPWR hold105/X sky130_fd_sc_hd__dlygate4sd3_1
X_4442_ _4735_/CLK _4442_/D fanout148/X VGND VGND VPWR VPWR _4442_/Q sky130_fd_sc_hd__dfrtp_1
Xhold116 _4665_/Q VGND VGND VPWR VPWR hold116/X sky130_fd_sc_hd__dlygate4sd3_1
XFILLER_104_209 VPWR VGND VPWR VGND sky130_ef_sc_hd__decap_12
XTAP_TAPCELL_ROW_96_1289 VGND VPWR sky130_fd_sc_hd__tapvpwrvgnd_1
Xhold149 _4578_/Q VGND VGND VPWR VPWR hold149/X sky130_fd_sc_hd__dlygate4sd3_1
Xhold127 _4660_/Q VGND VGND VPWR VPWR hold127/X sky130_fd_sc_hd__dlygate4sd3_1
Xhold138 _4576_/Q VGND VGND VPWR VPWR hold138/X sky130_fd_sc_hd__dlygate4sd3_1
XFILLER_98_421 VPWR VGND VPWR VGND sky130_ef_sc_hd__decap_12
X_4373_ _4727_/CLK _4373_/D fanout150/X VGND VGND VPWR VPWR hold59/A sky130_fd_sc_hd__dfrtp_1
X_3324_ _3325_/A _3325_/B _3325_/C VGND VGND VPWR VPWR _3346_/B sky130_fd_sc_hd__a21o_1
X_3255_ _3255_/A _3255_/B VGND VGND VPWR VPWR _3988_/A sky130_fd_sc_hd__xnor2_2
X_2206_ _4710_/Q VGND VGND VPWR VPWR _2206_/Y sky130_fd_sc_hd__inv_2
X_3186_ _3186_/A _3186_/B VGND VGND VPWR VPWR _3189_/B sky130_fd_sc_hd__xnor2_2
XFILLER_39_587 VGND VGND VPWR VPWR sky130_fd_sc_hd__decap_4
XFILLER_54_513 VGND VGND VPWR VPWR sky130_fd_sc_hd__decap_4
XFILLER_93_181 VGND VGND VPWR VPWR sky130_fd_sc_hd__decap_3
XFILLER_93_192 VPWR VGND VPWR VGND sky130_ef_sc_hd__decap_12
XFILLER_26_248 VGND VGND VPWR VPWR sky130_fd_sc_hd__decap_4
XFILLER_54_557 VPWR VGND VPWR VGND sky130_ef_sc_hd__decap_12
XTAP_TAPCELL_ROW_105_1385 VGND VPWR sky130_fd_sc_hd__tapvpwrvgnd_1
XFILLER_22_421 VGND VGND VPWR VPWR sky130_fd_sc_hd__decap_8
X_4709_ _4712_/CLK _4709_/D fanout165/X VGND VGND VPWR VPWR _4709_/Q sky130_fd_sc_hd__dfrtp_1
XFILLER_78_15 VPWR VGND VPWR VGND sky130_ef_sc_hd__decap_12
XFILLER_89_410 VPWR VGND VPWR VGND sky130_ef_sc_hd__decap_12
XTAP_TAPCELL_ROW_73_1031 VGND VPWR sky130_fd_sc_hd__tapvpwrvgnd_1
XFILLER_1_325 VGND VGND VPWR VPWR sky130_fd_sc_hd__decap_4
XFILLER_45_502 VGND VGND VPWR VPWR sky130_fd_sc_hd__fill_2
XTAP_TAPCELL_ROW_84_1160 VGND VPWR sky130_fd_sc_hd__tapvpwrvgnd_1
XTAP_TAPCELL_ROW_43_703 VGND VPWR sky130_fd_sc_hd__tapvpwrvgnd_1
XFILLER_25_281 VGND VGND VPWR VPWR sky130_fd_sc_hd__fill_2
XFILLER_43_51 VGND VGND VPWR VPWR sky130_fd_sc_hd__decap_4
XTAP_TAPCELL_ROW_23_482 VGND VPWR sky130_fd_sc_hd__tapvpwrvgnd_1
XTAP_TAPCELL_ROW_51_791 VGND VPWR sky130_fd_sc_hd__tapvpwrvgnd_1
XFILLER_4_185 VGND VGND VPWR VPWR sky130_fd_sc_hd__fill_2
X_3040_ _3007_/B _3012_/B _3007_/A VGND VGND VPWR VPWR _3041_/B sky130_fd_sc_hd__a21bo_1
XFILLER_36_513 VGND VGND VPWR VPWR sky130_fd_sc_hd__fill_1
XTAP_TAPCELL_ROW_59_880 VGND VPWR sky130_fd_sc_hd__tapvpwrvgnd_1
XFILLER_90_195 VGND VGND VPWR VPWR sky130_fd_sc_hd__fill_1
X_3942_ _3942_/A _3964_/A VGND VGND VPWR VPWR _3943_/C sky130_fd_sc_hd__or2_1
X_3873_ _3893_/B _3873_/B VGND VGND VPWR VPWR _3876_/A sky130_fd_sc_hd__and2_1
XTAP_TAPCELL_ROW_98_1307 VGND VPWR sky130_fd_sc_hd__tapvpwrvgnd_1
XFILLER_31_284 VGND VGND VPWR VPWR sky130_fd_sc_hd__decap_8
XFILLER_31_295 VGND VGND VPWR VPWR sky130_fd_sc_hd__fill_2
X_2824_ _2919_/A _2824_/B VGND VGND VPWR VPWR _2825_/B sky130_fd_sc_hd__xor2_1
X_2755_ _4499_/Q _2755_/B VGND VGND VPWR VPWR _2758_/B sky130_fd_sc_hd__xor2_2
X_2686_ _4496_/Q _2686_/B VGND VGND VPWR VPWR _2688_/A sky130_fd_sc_hd__xor2_4
XFILLER_105_529 VPWR VGND VPWR VGND sky130_ef_sc_hd__decap_12
X_4425_ _4539_/CLK _4425_/D fanout169/X VGND VGND VPWR VPWR _4425_/Q sky130_fd_sc_hd__dfrtp_1
X_4356_ _4724_/CLK _4356_/D fanout156/X VGND VGND VPWR VPWR _4356_/Q sky130_fd_sc_hd__dfstp_1
XFILLER_98_251 VGND VGND VPWR VPWR sky130_fd_sc_hd__fill_1
X_3307_ _3396_/A _3495_/A VGND VGND VPWR VPWR _3307_/X sky130_fd_sc_hd__and2_1
XFILLER_48_29 VPWR VGND VPWR VGND sky130_ef_sc_hd__decap_12
X_4287_ _4484_/Q _4287_/B VGND VGND VPWR VPWR _4287_/Y sky130_fd_sc_hd__xnor2_1
XFILLER_100_245 VGND VGND VPWR VPWR sky130_fd_sc_hd__decap_6
XFILLER_86_468 VGND VGND VPWR VPWR sky130_fd_sc_hd__decap_8
X_3238_ _3215_/A _3212_/Y _3214_/B VGND VGND VPWR VPWR _3239_/B sky130_fd_sc_hd__o21ai_1
XTAP_TAPCELL_ROW_107_1425 VGND VPWR sky130_fd_sc_hd__tapvpwrvgnd_1
XTAP_TAPCELL_ROW_107_1414 VGND VPWR sky130_fd_sc_hd__tapvpwrvgnd_1
XFILLER_100_289 VPWR VGND VPWR VGND sky130_ef_sc_hd__decap_12
X_3169_ _3127_/A _3149_/A _3147_/Y VGND VGND VPWR VPWR _3169_/Y sky130_fd_sc_hd__o21ai_1
XFILLER_54_321 VGND VGND VPWR VPWR sky130_fd_sc_hd__fill_1
XFILLER_54_354 VGND VGND VPWR VPWR sky130_fd_sc_hd__fill_1
Xfanout22 _3522_/B VGND VGND VPWR VPWR _3983_/S1 sky130_fd_sc_hd__clkbuf_2
XFILLER_80_27 VGND VGND VPWR VPWR sky130_fd_sc_hd__fill_1
Xfanout55 _4008_/X VGND VGND VPWR VPWR _4132_/A1 sky130_fd_sc_hd__clkbuf_4
Xfanout44 _2261_/X VGND VGND VPWR VPWR _2486_/A1 sky130_fd_sc_hd__buf_2
Xfanout33 _4206_/A1 VGND VGND VPWR VPWR _4213_/A1 sky130_fd_sc_hd__buf_2
Xfanout88 _3081_/A2 VGND VGND VPWR VPWR _4354_/A2 sky130_fd_sc_hd__buf_2
XFILLER_10_413 VGND VGND VPWR VPWR sky130_fd_sc_hd__decap_6
Xfanout99 _3257_/A VGND VGND VPWR VPWR _3278_/A sky130_fd_sc_hd__buf_2
Xfanout66 fanout67/X VGND VGND VPWR VPWR _4262_/A sky130_fd_sc_hd__buf_2
Xfanout77 _2259_/X VGND VGND VPWR VPWR _4355_/B2 sky130_fd_sc_hd__buf_2
XFILLER_10_457 VPWR VGND VPWR VGND sky130_ef_sc_hd__decap_12
XTAP_TAPCELL_ROW_20_452 VGND VPWR sky130_fd_sc_hd__tapvpwrvgnd_1
XFILLER_89_69 VGND VGND VPWR VPWR sky130_fd_sc_hd__decap_6
XFILLER_2_601 VPWR VGND VPWR VGND sky130_ef_sc_hd__decap_12
XFILLER_8_3 VPWR VGND VPWR VGND sky130_ef_sc_hd__decap_12
XFILLER_1_111 VGND VGND VPWR VPWR sky130_fd_sc_hd__fill_1
XFILLER_1_144 VGND VGND VPWR VPWR sky130_fd_sc_hd__decap_4
XFILLER_92_405 VPWR VGND VPWR VGND sky130_ef_sc_hd__decap_12
XFILLER_45_321 VGND VGND VPWR VPWR sky130_fd_sc_hd__decap_8
XTAP_TAPCELL_ROW_28_541 VGND VPWR sky130_fd_sc_hd__tapvpwrvgnd_1
XTAP_TAPCELL_ROW_56_850 VGND VPWR sky130_fd_sc_hd__tapvpwrvgnd_1
XFILLER_72_173 VGND VGND VPWR VPWR sky130_fd_sc_hd__decap_3
XFILLER_54_61 VGND VGND VPWR VPWR sky130_fd_sc_hd__decap_3
Xclkload25 _4761_/CLK VGND VGND VPWR VPWR clkload25/Y sky130_fd_sc_hd__inv_6
XFILLER_9_288 VPWR VGND VPWR VGND sky130_ef_sc_hd__decap_12
Xclkload14 _4509_/CLK VGND VGND VPWR VPWR clkload14/Y sky130_fd_sc_hd__clkinv_2
Xclkload36 _4527_/CLK VGND VGND VPWR VPWR clkload36/Y sky130_fd_sc_hd__inv_8
Xclkload47 _4536_/CLK VGND VGND VPWR VPWR clkload47/Y sky130_fd_sc_hd__bufinv_16
X_2540_ _4475_/Q _4474_/Q _4473_/Q VGND VGND VPWR VPWR _2540_/Y sky130_fd_sc_hd__nand3_1
X_2471_ _2471_/A _2471_/B VGND VGND VPWR VPWR _2475_/B sky130_fd_sc_hd__nor2_1
XTAP_TAPCELL_ROW_93_1259 VGND VPWR sky130_fd_sc_hd__tapvpwrvgnd_1
X_4210_ _4213_/A1 _4207_/X _4209_/Y _4217_/B1 hold230/X VGND VGND VPWR VPWR _4700_/D
+ sky130_fd_sc_hd__a32o_1
X_4141_ hold108/X _4008_/X _4148_/S VGND VGND VPWR VPWR _4669_/D sky130_fd_sc_hd__mux2_1
X_4072_ _4135_/A1 hold180/X _4076_/S VGND VGND VPWR VPWR _4608_/D sky130_fd_sc_hd__mux2_1
XFILLER_83_449 VPWR VGND VPWR VGND sky130_ef_sc_hd__decap_12
X_3023_ _3023_/A _3023_/B VGND VGND VPWR VPWR _3025_/B sky130_fd_sc_hd__xnor2_1
XFILLER_36_365 VGND VGND VPWR VPWR sky130_fd_sc_hd__decap_4
XFILLER_51_346 VPWR VGND VPWR VGND sky130_ef_sc_hd__decap_12
XTAP_TAPCELL_ROW_102_1355 VGND VPWR sky130_fd_sc_hd__tapvpwrvgnd_1
X_3925_ _3925_/A _3925_/B VGND VGND VPWR VPWR _3926_/B sky130_fd_sc_hd__xnor2_1
X_3856_ _3856_/A _3856_/B _3856_/C VGND VGND VPWR VPWR _3857_/B sky130_fd_sc_hd__and3_1
Xclkload8 clkload8/A VGND VGND VPWR VPWR clkload8/Y sky130_fd_sc_hd__bufinv_16
X_3787_ _3787_/A _3787_/B VGND VGND VPWR VPWR _3788_/B sky130_fd_sc_hd__xnor2_1
X_2807_ _2807_/A _2807_/B VGND VGND VPWR VPWR _2808_/C sky130_fd_sc_hd__or2_1
X_2738_ _4744_/Q _2717_/B _2721_/A VGND VGND VPWR VPWR _2751_/A sky130_fd_sc_hd__a21oi_1
XFILLER_105_337 VPWR VGND VPWR VGND sky130_ef_sc_hd__decap_12
X_4408_ _4495_/CLK _4408_/D fanout147/X VGND VGND VPWR VPWR _4408_/Q sky130_fd_sc_hd__dfrtp_1
X_2669_ _4563_/Q _4595_/Q hold84/A _4659_/Q _3257_/A _2747_/A VGND VGND VPWR VPWR
+ _2672_/B sky130_fd_sc_hd__mux4_2
XFILLER_59_39 VPWR VGND VPWR VGND sky130_ef_sc_hd__decap_12
XTAP_TAPCELL_ROW_70_1001 VGND VPWR sky130_fd_sc_hd__tapvpwrvgnd_1
XFILLER_59_413 VGND VGND VPWR VPWR sky130_fd_sc_hd__fill_1
XFILLER_59_446 VGND VGND VPWR VPWR sky130_fd_sc_hd__fill_2
X_4339_ _4751_/Q _4339_/A2 _3601_/A _4339_/B2 VGND VGND VPWR VPWR _4751_/D sky130_fd_sc_hd__a22o_1
XFILLER_75_27 VPWR VGND VPWR VGND sky130_ef_sc_hd__decap_12
XFILLER_91_15 VPWR VGND VPWR VGND sky130_ef_sc_hd__decap_12
XFILLER_15_505 VGND VGND VPWR VPWR sky130_fd_sc_hd__decap_4
XTAP_TAPCELL_ROW_25_511 VGND VPWR sky130_fd_sc_hd__tapvpwrvgnd_1
XTAP_TAPCELL_ROW_53_820 VGND VPWR sky130_fd_sc_hd__tapvpwrvgnd_1
XFILLER_24_53 VPWR VGND VPWR VGND sky130_ef_sc_hd__decap_12
XFILLER_24_97 VGND VGND VPWR VPWR sky130_fd_sc_hd__decap_3
XFILLER_6_236 VGND VGND VPWR VPWR sky130_fd_sc_hd__fill_1
XFILLER_40_41 VPWR VGND VPWR VGND sky130_ef_sc_hd__decap_12
XFILLER_2_464 VGND VGND VPWR VPWR sky130_fd_sc_hd__fill_2
XFILLER_2_475 VGND VGND VPWR VPWR sky130_fd_sc_hd__fill_1
XTAP_TAPCELL_ROW_5_291 VGND VPWR sky130_fd_sc_hd__tapvpwrvgnd_1
XFILLER_65_449 VPWR VGND VPWR VGND sky130_ef_sc_hd__decap_12
Xclkbuf_leaf_57_clk clkload0/A VGND VGND VPWR VPWR _4656_/CLK sky130_fd_sc_hd__clkbuf_8
XFILLER_1_57 VPWR VGND VPWR VGND sky130_ef_sc_hd__decap_12
XFILLER_46_630 VGND VGND VPWR VPWR sky130_fd_sc_hd__decap_6
XFILLER_92_268 VGND VGND VPWR VPWR sky130_fd_sc_hd__fill_1
XFILLER_18_365 VGND VGND VPWR VPWR sky130_fd_sc_hd__fill_1
X_3710_ _3710_/A _3710_/B VGND VGND VPWR VPWR _3713_/B sky130_fd_sc_hd__xnor2_1
X_4690_ _4724_/CLK _4690_/D fanout156/X VGND VGND VPWR VPWR _4690_/Q sky130_fd_sc_hd__dfrtp_2
XTAP_TAPCELL_ROW_31_569 VGND VPWR sky130_fd_sc_hd__tapvpwrvgnd_1
X_3641_ _4538_/Q _3642_/B VGND VGND VPWR VPWR _3664_/A sky130_fd_sc_hd__and2_1
X_3572_ _3572_/A _3572_/B VGND VGND VPWR VPWR _3573_/B sky130_fd_sc_hd__or2_1
XFILLER_60_3 VPWR VGND VPWR VGND sky130_ef_sc_hd__decap_12
X_2523_ _2525_/B _2522_/Y _4468_/Q _2535_/A2 VGND VGND VPWR VPWR _4468_/D sky130_fd_sc_hd__a2bb2o_1
XFILLER_102_307 VGND VGND VPWR VPWR sky130_fd_sc_hd__fill_1
X_2454_ _4448_/Q _2455_/B VGND VGND VPWR VPWR _2459_/B sky130_fd_sc_hd__nand2_1
X_2385_ hold211/X _2414_/A2 _2414_/B1 _4550_/Q VGND VGND VPWR VPWR _4400_/D sky130_fd_sc_hd__a22o_1
X_4124_ hold294/X _4133_/A1 _4130_/S VGND VGND VPWR VPWR _4654_/D sky130_fd_sc_hd__mux2_1
Xinput1 rst_n VGND VGND VPWR VPWR input1/X sky130_fd_sc_hd__clkbuf_1
XFILLER_56_416 VGND VGND VPWR VPWR sky130_fd_sc_hd__decap_4
XTAP_TAPCELL_ROW_67_967 VGND VPWR sky130_fd_sc_hd__tapvpwrvgnd_1
X_4055_ _4136_/A1 hold183/X _4058_/S VGND VGND VPWR VPWR _4593_/D sky130_fd_sc_hd__mux2_1
XTAP_TAPCELL_ROW_39_658 VGND VPWR sky130_fd_sc_hd__tapvpwrvgnd_1
Xclkbuf_leaf_48_clk clkload5/A VGND VGND VPWR VPWR _4504_/CLK sky130_fd_sc_hd__clkbuf_8
X_3006_ _4756_/Q _3006_/B VGND VGND VPWR VPWR _3007_/B sky130_fd_sc_hd__or2_1
XFILLER_36_195 VGND VGND VPWR VPWR sky130_fd_sc_hd__fill_1
XFILLER_52_622 VPWR VGND VPWR VGND sky130_ef_sc_hd__decap_12
XFILLER_101_69 VPWR VGND VPWR VGND sky130_ef_sc_hd__decap_12
X_3908_ _4549_/Q _3908_/B VGND VGND VPWR VPWR _3931_/B sky130_fd_sc_hd__xnor2_1
XFILLER_20_541 VGND VGND VPWR VPWR sky130_fd_sc_hd__decap_6
X_3839_ _3839_/A _3839_/B _3839_/C _3839_/D VGND VGND VPWR VPWR _3843_/B sky130_fd_sc_hd__and4_1
XFILLER_106_613 VPWR VGND VPWR VGND sky130_ef_sc_hd__decap_12
XFILLER_3_228 VGND VGND VPWR VPWR sky130_fd_sc_hd__fill_1
XFILLER_105_167 VGND VGND VPWR VPWR sky130_fd_sc_hd__fill_1
XFILLER_10_77 VGND VGND VPWR VPWR sky130_fd_sc_hd__decap_6
XFILLER_86_15 VPWR VGND VPWR VGND sky130_ef_sc_hd__decap_12
XFILLER_87_541 VPWR VGND VPWR VGND sky130_ef_sc_hd__decap_12
XFILLER_101_373 VPWR VGND VPWR VGND sky130_ef_sc_hd__decap_12
XFILLER_87_585 VPWR VGND VPWR VGND sky130_ef_sc_hd__decap_12
XFILLER_74_213 VPWR VGND VPWR VGND sky130_ef_sc_hd__decap_12
Xclkbuf_leaf_39_clk _4459_/CLK VGND VGND VPWR VPWR _4699_/CLK sky130_fd_sc_hd__clkbuf_8
XFILLER_28_630 VGND VGND VPWR VPWR sky130_fd_sc_hd__fill_1
XTAP_TAPCELL_ROW_2_250 VGND VPWR sky130_fd_sc_hd__tapvpwrvgnd_1
XFILLER_27_184 VPWR VGND VPWR VGND sky130_ef_sc_hd__decap_12
XFILLER_55_493 VGND VGND VPWR VPWR sky130_fd_sc_hd__fill_1
XFILLER_15_368 VGND VGND VPWR VPWR sky130_fd_sc_hd__fill_1
XFILLER_42_187 VGND VGND VPWR VPWR sky130_fd_sc_hd__fill_2
XFILLER_11_552 VGND VGND VPWR VPWR sky130_fd_sc_hd__decap_8
XFILLER_51_51 VGND VGND VPWR VPWR sky130_fd_sc_hd__decap_4
XFILLER_97_305 VPWR VGND VPWR VGND sky130_ef_sc_hd__decap_12
XTAP_TAPCELL_ROW_90_1218 VGND VPWR sky130_fd_sc_hd__tapvpwrvgnd_1
XFILLER_97_349 VPWR VGND VPWR VGND sky130_ef_sc_hd__decap_12
XFILLER_2_272 VGND VGND VPWR VPWR sky130_fd_sc_hd__decap_3
XFILLER_65_257 VGND VGND VPWR VPWR sky130_fd_sc_hd__fill_1
XFILLER_80_249 VGND VGND VPWR VPWR sky130_fd_sc_hd__decap_3
XFILLER_80_227 VGND VGND VPWR VPWR sky130_fd_sc_hd__fill_1
XTAP_TAPCELL_ROW_64_937 VGND VPWR sky130_fd_sc_hd__tapvpwrvgnd_1
XFILLER_34_622 VGND VGND VPWR VPWR sky130_fd_sc_hd__decap_6
XTAP_TAPCELL_ROW_36_628 VGND VPWR sky130_fd_sc_hd__tapvpwrvgnd_1
XFILLER_61_496 VGND VGND VPWR VPWR sky130_fd_sc_hd__decap_8
X_4742_ clkload9/A _4742_/D fanout123/X VGND VGND VPWR VPWR _4742_/Q sky130_fd_sc_hd__dfrtp_2
X_4673_ _4756_/CLK _4673_/D fanout135/X VGND VGND VPWR VPWR _4673_/Q sky130_fd_sc_hd__dfrtp_1
X_3624_ _3577_/A _3577_/B _3623_/X _3622_/X VGND VGND VPWR VPWR _3626_/B sky130_fd_sc_hd__a31o_1
X_3555_ _3556_/B _3556_/C _3556_/A VGND VGND VPWR VPWR _3558_/B sky130_fd_sc_hd__a21o_1
X_3486_ _3526_/A _3486_/B VGND VGND VPWR VPWR _3487_/B sky130_fd_sc_hd__xnor2_1
X_2506_ _2534_/A2 _2509_/B _2505_/X _2535_/A2 hold249/X VGND VGND VPWR VPWR _4463_/D
+ sky130_fd_sc_hd__a32o_1
XFILLER_88_349 VPWR VGND VPWR VGND sky130_ef_sc_hd__decap_12
X_2437_ _2438_/A _2438_/B VGND VGND VPWR VPWR _2442_/B sky130_fd_sc_hd__or2_1
XFILLER_69_541 VPWR VGND VPWR VGND sky130_ef_sc_hd__decap_12
XFILLER_69_585 VPWR VGND VPWR VGND sky130_ef_sc_hd__decap_12
X_2368_ hold25/X _2375_/A2 _2375_/B1 _4533_/Q VGND VGND VPWR VPWR _4383_/D sky130_fd_sc_hd__a22o_1
XFILLER_56_29 VPWR VGND VPWR VGND sky130_ef_sc_hd__decap_12
XFILLER_84_533 VPWR VGND VPWR VGND sky130_ef_sc_hd__decap_12
X_2299_ _4692_/Q _2185_/Y _4693_/Q _2459_/A VGND VGND VPWR VPWR _2299_/X sky130_fd_sc_hd__o22a_1
XFILLER_29_449 VGND VGND VPWR VPWR sky130_fd_sc_hd__decap_8
X_4107_ hold96/X _4020_/X _4112_/S VGND VGND VPWR VPWR _4639_/D sky130_fd_sc_hd__mux2_1
X_4038_ _4137_/A1 hold149/X _4040_/S VGND VGND VPWR VPWR _4578_/D sky130_fd_sc_hd__mux2_1
XFILLER_56_279 VGND VGND VPWR VPWR sky130_fd_sc_hd__decap_4
XFILLER_25_622 VGND VGND VPWR VPWR sky130_fd_sc_hd__decap_6
XFILLER_12_305 VGND VGND VPWR VPWR sky130_fd_sc_hd__decap_3
XFILLER_106_421 VPWR VGND VPWR VGND sky130_ef_sc_hd__decap_12
XTAP_TAPCELL_ROW_76_1073 VGND VPWR sky130_fd_sc_hd__tapvpwrvgnd_1
XFILLER_97_69 VPWR VGND VPWR VGND sky130_ef_sc_hd__decap_12
XFILLER_87_382 VGND VGND VPWR VPWR sky130_fd_sc_hd__decap_8
XFILLER_47_213 VGND VGND VPWR VPWR sky130_fd_sc_hd__decap_3
XFILLER_101_181 VPWR VGND VPWR VGND sky130_ef_sc_hd__decap_12
XFILLER_87_393 VGND VGND VPWR VPWR sky130_fd_sc_hd__decap_4
XFILLER_47_279 VGND VGND VPWR VPWR sky130_fd_sc_hd__fill_1
XFILLER_90_525 VGND VGND VPWR VPWR sky130_fd_sc_hd__decap_6
XFILLER_62_216 VGND VGND VPWR VPWR sky130_fd_sc_hd__decap_3
XFILLER_46_73 VGND VGND VPWR VPWR sky130_fd_sc_hd__decap_3
XFILLER_90_569 VPWR VGND VPWR VGND sky130_ef_sc_hd__decap_12
XTAP_TAPCELL_ROW_87_1191 VGND VPWR sky130_fd_sc_hd__tapvpwrvgnd_1
XTAP_TAPCELL_ROW_61_907 VGND VPWR sky130_fd_sc_hd__tapvpwrvgnd_1
XFILLER_62_83 VGND VGND VPWR VPWR sky130_fd_sc_hd__fill_1
XTAP_TAPCELL_ROW_13_377 VGND VPWR sky130_fd_sc_hd__tapvpwrvgnd_1
XFILLER_7_320 VGND VGND VPWR VPWR sky130_fd_sc_hd__decap_4
XTAP_TAPCELL_ROW_41_686 VGND VPWR sky130_fd_sc_hd__tapvpwrvgnd_1
X_3340_ _3369_/B _3340_/B VGND VGND VPWR VPWR _3343_/A sky130_fd_sc_hd__nor2_1
XFILLER_98_625 VPWR VGND VPWR VGND sky130_ef_sc_hd__decap_12
XFILLER_97_113 VPWR VGND VPWR VGND sky130_ef_sc_hd__decap_12
X_3271_ _3272_/A _3451_/A VGND VGND VPWR VPWR _3293_/A sky130_fd_sc_hd__nand2_1
X_2222_ _4558_/Q VGND VGND VPWR VPWR _2222_/Y sky130_fd_sc_hd__inv_2
XFILLER_23_3 VPWR VGND VPWR VGND sky130_ef_sc_hd__decap_12
XFILLER_78_393 VGND VGND VPWR VPWR sky130_fd_sc_hd__fill_1
XFILLER_66_533 VPWR VGND VPWR VGND sky130_ef_sc_hd__decap_12
XFILLER_81_503 VGND VGND VPWR VPWR sky130_fd_sc_hd__fill_1
XTAP_TAPCELL_ROW_49_775 VGND VPWR sky130_fd_sc_hd__tapvpwrvgnd_1
XFILLER_19_482 VPWR VGND VPWR VGND sky130_ef_sc_hd__decap_12
XFILLER_61_260 VGND VGND VPWR VPWR sky130_fd_sc_hd__decap_3
XFILLER_22_603 VPWR VGND VPWR VGND sky130_ef_sc_hd__decap_12
XFILLER_22_625 VPWR VGND VPWR VGND sky130_ef_sc_hd__decap_12
XFILLER_34_485 VGND VGND VPWR VPWR sky130_fd_sc_hd__fill_2
XFILLER_21_113 VGND VGND VPWR VPWR sky130_fd_sc_hd__decap_6
X_2986_ _4755_/Q _2986_/B VGND VGND VPWR VPWR _2987_/B sky130_fd_sc_hd__nand2_1
X_4725_ _4726_/CLK _4725_/D fanout160/X VGND VGND VPWR VPWR uo_out[6] sky130_fd_sc_hd__dfrtp_4
X_4656_ _4656_/CLK _4656_/D fanout120/X VGND VGND VPWR VPWR _4656_/Q sky130_fd_sc_hd__dfrtp_1
X_4587_ _4764_/CLK _4587_/D fanout141/X VGND VGND VPWR VPWR _4587_/Q sky130_fd_sc_hd__dfrtp_1
X_3607_ _3606_/A _3606_/B _3606_/C VGND VGND VPWR VPWR _3608_/C sky130_fd_sc_hd__a21o_1
X_3538_ _3538_/A _3538_/B VGND VGND VPWR VPWR _3538_/X sky130_fd_sc_hd__xor2_1
XFILLER_107_57 VPWR VGND VPWR VGND sky130_ef_sc_hd__decap_12
XFILLER_88_135 VGND VGND VPWR VPWR sky130_fd_sc_hd__decap_4
XFILLER_67_39 VPWR VGND VPWR VGND sky130_ef_sc_hd__decap_12
X_3469_ _3467_/A _3466_/A _3467_/B _3468_/X VGND VGND VPWR VPWR _3469_/X sky130_fd_sc_hd__a31o_1
XFILLER_29_202 VGND VGND VPWR VPWR sky130_fd_sc_hd__decap_3
XFILLER_84_363 VGND VGND VPWR VPWR sky130_fd_sc_hd__fill_1
XFILLER_29_279 VGND VGND VPWR VPWR sky130_fd_sc_hd__fill_1
XFILLER_83_27 VPWR VGND VPWR VGND sky130_ef_sc_hd__decap_12
XFILLER_72_525 VGND VGND VPWR VPWR sky130_fd_sc_hd__decap_6
XFILLER_72_569 VPWR VGND VPWR VGND sky130_ef_sc_hd__decap_12
XFILLER_25_430 VGND VGND VPWR VPWR sky130_fd_sc_hd__fill_1
XFILLER_13_625 VGND VGND VPWR VPWR sky130_fd_sc_hd__decap_3
XFILLER_16_65 VPWR VGND VPWR VGND sky130_ef_sc_hd__decap_12
XFILLER_13_636 VGND VGND VPWR VPWR sky130_fd_sc_hd__fill_1
XFILLER_9_629 VGND VGND VPWR VPWR sky130_fd_sc_hd__decap_8
XFILLER_40_477 VGND VGND VPWR VPWR sky130_fd_sc_hd__decap_8
XFILLER_32_53 VGND VGND VPWR VPWR sky130_fd_sc_hd__decap_8
XTAP_TAPCELL_ROW_10_347 VGND VPWR sky130_fd_sc_hd__tapvpwrvgnd_1
XFILLER_20_190 VGND VGND VPWR VPWR sky130_fd_sc_hd__decap_6
XFILLER_106_251 VGND VGND VPWR VPWR sky130_fd_sc_hd__fill_1
XFILLER_4_345 VPWR VGND VPWR VGND sky130_ef_sc_hd__decap_12
XFILLER_79_113 VGND VGND VPWR VPWR sky130_fd_sc_hd__decap_4
XFILLER_95_617 VPWR VGND VPWR VGND sky130_ef_sc_hd__decap_12
XFILLER_0_573 VPWR VGND VPWR VGND sky130_ef_sc_hd__decap_12
XFILLER_48_511 VPWR VGND VPWR VGND sky130_ef_sc_hd__decap_12
XFILLER_48_533 VPWR VGND VPWR VGND sky130_ef_sc_hd__decap_12
XTAP_TAPCELL_ROW_18_425 VGND VPWR sky130_fd_sc_hd__tapvpwrvgnd_1
XTAP_TAPCELL_ROW_46_734 VGND VPWR sky130_fd_sc_hd__tapvpwrvgnd_1
XFILLER_35_249 VGND VGND VPWR VPWR sky130_fd_sc_hd__decap_8
XFILLER_31_411 VGND VGND VPWR VPWR sky130_fd_sc_hd__decap_3
XFILLER_50_208 VPWR VGND VPWR VGND sky130_ef_sc_hd__decap_12
X_2840_ _2838_/Y _2840_/B VGND VGND VPWR VPWR _2842_/A sky130_fd_sc_hd__nand2b_1
XFILLER_43_293 VPWR VGND VPWR VGND sky130_ef_sc_hd__decap_12
X_2771_ _2771_/A _2771_/B VGND VGND VPWR VPWR _2819_/A sky130_fd_sc_hd__nand2_1
X_4510_ _4513_/CLK _4510_/D fanout143/X VGND VGND VPWR VPWR _4510_/Q sky130_fd_sc_hd__dfrtp_1
Xhold106 _4678_/Q VGND VGND VPWR VPWR hold106/X sky130_fd_sc_hd__dlygate4sd3_1
X_4441_ _4727_/CLK _4441_/D fanout156/X VGND VGND VPWR VPWR _4441_/Q sky130_fd_sc_hd__dfrtp_1
Xhold117 _4444_/Q VGND VGND VPWR VPWR hold117/X sky130_fd_sc_hd__dlygate4sd3_1
Xhold128 _4575_/Q VGND VGND VPWR VPWR hold128/X sky130_fd_sc_hd__dlygate4sd3_1
XPHY_EDGE_ROW_9_Right_9 VGND VGND VPWR VPWR sky130_fd_sc_hd__decap_3
Xhold139 _4626_/Q VGND VGND VPWR VPWR hold139/X sky130_fd_sc_hd__dlygate4sd3_1
X_4372_ _4727_/CLK _4372_/D fanout150/X VGND VGND VPWR VPWR _4372_/Q sky130_fd_sc_hd__dfrtp_1
XFILLER_98_433 VPWR VGND VPWR VGND sky130_ef_sc_hd__decap_12
X_3323_ _3346_/A _3323_/B VGND VGND VPWR VPWR _3325_/C sky130_fd_sc_hd__nand2_1
XPHY_EDGE_ROW_107_Right_107 VGND VGND VPWR VPWR sky130_fd_sc_hd__decap_3
XFILLER_98_477 VPWR VGND VPWR VGND sky130_ef_sc_hd__decap_12
X_3254_ _3254_/A _3254_/B VGND VGND VPWR VPWR _3255_/B sky130_fd_sc_hd__xnor2_1
X_2205_ _4468_/Q VGND VGND VPWR VPWR _2521_/A sky130_fd_sc_hd__inv_2
X_3185_ _3185_/A _3185_/B VGND VGND VPWR VPWR _3186_/B sky130_fd_sc_hd__xor2_1
XFILLER_26_227 VGND VGND VPWR VPWR sky130_fd_sc_hd__fill_1
XFILLER_39_599 VPWR VGND VPWR VGND sky130_ef_sc_hd__decap_12
XFILLER_54_569 VPWR VGND VPWR VGND sky130_ef_sc_hd__decap_12
XFILLER_81_399 VGND VGND VPWR VPWR sky130_fd_sc_hd__fill_1
XTAP_TAPCELL_ROW_105_1386 VGND VPWR sky130_fd_sc_hd__tapvpwrvgnd_1
XFILLER_22_477 VGND VGND VPWR VPWR sky130_fd_sc_hd__decap_6
X_2969_ _4540_/Q _2970_/B VGND VGND VPWR VPWR _2971_/A sky130_fd_sc_hd__nand2_1
XFILLER_5_109 VGND VGND VPWR VPWR sky130_fd_sc_hd__decap_3
X_4708_ _4708_/CLK _4708_/D fanout165/X VGND VGND VPWR VPWR _4708_/Q sky130_fd_sc_hd__dfrtp_1
X_4639_ _4752_/CLK _4639_/D fanout135/X VGND VGND VPWR VPWR hold96/A sky130_fd_sc_hd__dfrtp_1
XFILLER_89_422 VPWR VGND VPWR VGND sky130_ef_sc_hd__decap_12
XFILLER_78_27 VGND VGND VPWR VPWR sky130_fd_sc_hd__fill_1
XTAP_TAPCELL_ROW_73_1032 VGND VPWR sky130_fd_sc_hd__tapvpwrvgnd_1
XFILLER_1_304 VGND VGND VPWR VPWR sky130_fd_sc_hd__fill_2
XFILLER_77_617 VPWR VGND VPWR VGND sky130_ef_sc_hd__decap_12
XFILLER_94_15 VPWR VGND VPWR VGND sky130_ef_sc_hd__decap_12
XFILLER_84_193 VGND VGND VPWR VPWR sky130_fd_sc_hd__decap_3
XFILLER_45_558 VGND VGND VPWR VPWR sky130_fd_sc_hd__fill_2
XTAP_TAPCELL_ROW_84_1161 VGND VPWR sky130_fd_sc_hd__tapvpwrvgnd_1
XFILLER_25_260 VGND VGND VPWR VPWR sky130_fd_sc_hd__fill_1
XTAP_TAPCELL_ROW_43_704 VGND VPWR sky130_fd_sc_hd__tapvpwrvgnd_1
XFILLER_13_499 VGND VGND VPWR VPWR sky130_fd_sc_hd__fill_2
XTAP_TAPCELL_ROW_23_483 VGND VPWR sky130_fd_sc_hd__tapvpwrvgnd_1
XTAP_TAPCELL_ROW_51_792 VGND VPWR sky130_fd_sc_hd__tapvpwrvgnd_1
XFILLER_95_447 VGND VGND VPWR VPWR sky130_fd_sc_hd__fill_1
XFILLER_83_609 VGND VGND VPWR VPWR sky130_fd_sc_hd__decap_6
XTAP_TAPCELL_ROW_59_881 VGND VPWR sky130_fd_sc_hd__tapvpwrvgnd_1
X_3941_ _3941_/A _3941_/B VGND VGND VPWR VPWR _3964_/A sky130_fd_sc_hd__and2_1
XFILLER_16_271 VGND VGND VPWR VPWR sky130_fd_sc_hd__fill_1
XFILLER_90_3 VPWR VGND VPWR VGND sky130_ef_sc_hd__decap_12
X_3872_ _4762_/Q _3872_/B VGND VGND VPWR VPWR _3873_/B sky130_fd_sc_hd__nand2_1
XTAP_TAPCELL_ROW_98_1308 VGND VPWR sky130_fd_sc_hd__tapvpwrvgnd_1
X_2823_ _2729_/B _2820_/Y _2822_/Y VGND VGND VPWR VPWR _2824_/B sky130_fd_sc_hd__a21oi_2
X_2754_ _4499_/Q _2755_/B VGND VGND VPWR VPWR _2782_/A sky130_fd_sc_hd__or2_1
X_2685_ _4496_/Q _2686_/B VGND VGND VPWR VPWR _2685_/X sky130_fd_sc_hd__and2_1
X_4424_ _4539_/CLK _4424_/D fanout169/X VGND VGND VPWR VPWR _4424_/Q sky130_fd_sc_hd__dfrtp_1
X_4355_ _4767_/Q _4355_/A2 _3985_/B _4355_/B2 VGND VGND VPWR VPWR _4767_/D sky130_fd_sc_hd__a22o_1
XFILLER_59_617 VPWR VGND VPWR VGND sky130_ef_sc_hd__decap_12
X_3306_ _3306_/A _3306_/B VGND VGND VPWR VPWR _3311_/A sky130_fd_sc_hd__xnor2_1
X_4286_ _4283_/A _4285_/Y _4283_/Y _2250_/A VGND VGND VPWR VPWR _4287_/B sky130_fd_sc_hd__a211o_1
X_3237_ _3237_/A _3237_/B VGND VGND VPWR VPWR _3239_/A sky130_fd_sc_hd__nand2_1
XTAP_TAPCELL_ROW_107_1415 VGND VPWR sky130_fd_sc_hd__tapvpwrvgnd_1
XTAP_TAPCELL_ROW_107_1404 VGND VPWR sky130_fd_sc_hd__tapvpwrvgnd_1
X_3168_ _4516_/Q _3168_/B VGND VGND VPWR VPWR _3171_/A sky130_fd_sc_hd__xor2_2
XFILLER_64_29 VPWR VGND VPWR VGND sky130_ef_sc_hd__decap_12
X_3099_ _3105_/B VGND VGND VPWR VPWR _3100_/C sky130_fd_sc_hd__inv_2
Xfanout45 _2261_/X VGND VGND VPWR VPWR _2482_/B1 sky130_fd_sc_hd__clkbuf_2
Xfanout34 _4238_/A1 VGND VGND VPWR VPWR _4206_/A1 sky130_fd_sc_hd__clkbuf_2
Xfanout23 _3268_/Y VGND VGND VPWR VPWR _3522_/B sky130_fd_sc_hd__buf_2
Xfanout56 fanout67/X VGND VGND VPWR VPWR _2408_/A2 sky130_fd_sc_hd__clkbuf_4
Xfanout78 _3794_/B2 VGND VGND VPWR VPWR _3978_/A sky130_fd_sc_hd__clkbuf_4
Xfanout89 _3081_/A2 VGND VGND VPWR VPWR _4355_/A2 sky130_fd_sc_hd__clkbuf_2
Xfanout67 _2355_/X VGND VGND VPWR VPWR fanout67/X sky130_fd_sc_hd__clkbuf_2
XFILLER_13_55 VGND VGND VPWR VPWR sky130_fd_sc_hd__fill_1
XFILLER_10_469 VGND VGND VPWR VPWR sky130_fd_sc_hd__decap_6
XFILLER_89_15 VPWR VGND VPWR VGND sky130_ef_sc_hd__decap_12
XTAP_TAPCELL_ROW_20_453 VGND VPWR sky130_fd_sc_hd__tapvpwrvgnd_1
XFILLER_2_613 VPWR VGND VPWR VGND sky130_ef_sc_hd__decap_12
XFILLER_89_230 VGND VGND VPWR VPWR sky130_fd_sc_hd__decap_3
Xstream_cipher_180 VGND VGND VPWR VPWR stream_cipher_180/HI uio_out[0] sky130_fd_sc_hd__conb_1
XFILLER_49_138 VPWR VGND VPWR VGND sky130_ef_sc_hd__decap_12
XFILLER_65_609 VGND VGND VPWR VPWR sky130_fd_sc_hd__decap_6
XFILLER_38_41 VPWR VGND VPWR VGND sky130_ef_sc_hd__decap_12
XFILLER_92_417 VGND VGND VPWR VPWR sky130_fd_sc_hd__decap_3
XFILLER_38_85 VPWR VGND VPWR VGND sky130_ef_sc_hd__decap_12
XFILLER_18_569 VGND VGND VPWR VPWR sky130_fd_sc_hd__decap_4
XTAP_TAPCELL_ROW_28_542 VGND VPWR sky130_fd_sc_hd__tapvpwrvgnd_1
XTAP_TAPCELL_ROW_56_851 VGND VPWR sky130_fd_sc_hd__tapvpwrvgnd_1
XFILLER_72_141 VGND VGND VPWR VPWR sky130_fd_sc_hd__decap_4
XFILLER_41_561 VGND VGND VPWR VPWR sky130_fd_sc_hd__decap_6
XFILLER_13_285 VGND VGND VPWR VPWR sky130_fd_sc_hd__fill_1
XFILLER_9_223 VGND VGND VPWR VPWR sky130_fd_sc_hd__fill_1
XFILLER_9_245 VPWR VGND VPWR VGND sky130_ef_sc_hd__decap_12
Xclkload26 _4767_/CLK VGND VGND VPWR VPWR clkload26/Y sky130_fd_sc_hd__clkinvlp_4
XFILLER_70_83 VGND VGND VPWR VPWR sky130_fd_sc_hd__fill_1
Xclkload15 _4499_/CLK VGND VGND VPWR VPWR clkload15/X sky130_fd_sc_hd__clkbuf_4
Xclkload37 _4726_/CLK VGND VGND VPWR VPWR clkload37/X sky130_fd_sc_hd__clkbuf_8
Xclkload48 _4504_/CLK VGND VGND VPWR VPWR clkload48/X sky130_fd_sc_hd__clkbuf_4
X_2470_ _2482_/B1 _2471_/B _2469_/X _2483_/B2 hold260/X VGND VGND VPWR VPWR _4452_/D
+ sky130_fd_sc_hd__a32o_1
XFILLER_79_81 VPWR VGND VPWR VGND sky130_ef_sc_hd__decap_12
X_4140_ _4113_/A _4140_/B _4362_/Q _4140_/D VGND VGND VPWR VPWR _4148_/S sky130_fd_sc_hd__and4b_4
XFILLER_68_425 VGND VGND VPWR VPWR sky130_fd_sc_hd__fill_1
X_4071_ _4134_/A1 hold155/X _4076_/S VGND VGND VPWR VPWR _4607_/D sky130_fd_sc_hd__mux2_1
X_3022_ _3022_/A _3022_/B VGND VGND VPWR VPWR _3023_/B sky130_fd_sc_hd__xnor2_1
XFILLER_91_461 VPWR VGND VPWR VGND sky130_ef_sc_hd__decap_12
XFILLER_63_185 VPWR VGND VPWR VGND sky130_ef_sc_hd__decap_12
X_3924_ _3903_/B _3905_/B _3903_/A VGND VGND VPWR VPWR _3925_/B sky130_fd_sc_hd__o21ba_1
XFILLER_51_358 VGND VGND VPWR VPWR sky130_fd_sc_hd__fill_1
XTAP_TAPCELL_ROW_102_1356 VGND VPWR sky130_fd_sc_hd__tapvpwrvgnd_1
X_3855_ _3856_/A _3856_/B _3856_/C VGND VGND VPWR VPWR _3878_/B sky130_fd_sc_hd__a21oi_1
Xclkload9 clkload9/A VGND VGND VPWR VPWR clkload9/Y sky130_fd_sc_hd__inv_8
X_3786_ _3741_/A _3785_/A _3785_/X VGND VGND VPWR VPWR _3787_/B sky130_fd_sc_hd__o21ai_1
X_2806_ _2841_/A _2806_/B VGND VGND VPWR VPWR _2813_/A sky130_fd_sc_hd__nand2_1
X_2737_ _4530_/Q _2723_/B _2728_/X VGND VGND VPWR VPWR _2752_/A sky130_fd_sc_hd__a21bo_1
XFILLER_105_305 VPWR VGND VPWR VGND sky130_ef_sc_hd__decap_12
X_2668_ _4495_/Q _4331_/A2 _3451_/A _2708_/B2 VGND VGND VPWR VPWR _4495_/D sky130_fd_sc_hd__a22o_1
XFILLER_105_349 VPWR VGND VPWR VGND sky130_ef_sc_hd__decap_12
X_4407_ _4495_/CLK _4407_/D fanout147/X VGND VGND VPWR VPWR _4407_/Q sky130_fd_sc_hd__dfrtp_1
XFILLER_99_561 VPWR VGND VPWR VGND sky130_ef_sc_hd__decap_12
XTAP_TAPCELL_ROW_70_1002 VGND VPWR sky130_fd_sc_hd__tapvpwrvgnd_1
X_2599_ _3382_/A _4522_/Q _2584_/B _2582_/X VGND VGND VPWR VPWR _2600_/B sky130_fd_sc_hd__a31o_1
X_4338_ hold293/X _4339_/A2 _3572_/A _4339_/B2 VGND VGND VPWR VPWR _4750_/D sky130_fd_sc_hd__a22o_1
XFILLER_59_469 VPWR VGND VPWR VGND sky130_ef_sc_hd__decap_12
X_4269_ _4283_/A _4269_/B VGND VGND VPWR VPWR _4269_/Y sky130_fd_sc_hd__nor2_1
XFILLER_75_39 VPWR VGND VPWR VGND sky130_ef_sc_hd__decap_12
XFILLER_39_160 VGND VGND VPWR VPWR sky130_fd_sc_hd__decap_3
XFILLER_46_119 VGND VGND VPWR VPWR sky130_fd_sc_hd__fill_1
XFILLER_70_601 VPWR VGND VPWR VGND sky130_ef_sc_hd__decap_12
XFILLER_91_27 VPWR VGND VPWR VGND sky130_ef_sc_hd__decap_12
XTAP_TAPCELL_ROW_25_512 VGND VPWR sky130_fd_sc_hd__tapvpwrvgnd_1
XTAP_TAPCELL_ROW_53_810 VGND VPWR sky130_fd_sc_hd__tapvpwrvgnd_1
XTAP_TAPCELL_ROW_81_1120 VGND VPWR sky130_fd_sc_hd__tapvpwrvgnd_1
XFILLER_23_561 VGND VGND VPWR VPWR sky130_fd_sc_hd__fill_1
XFILLER_24_65 VPWR VGND VPWR VGND sky130_ef_sc_hd__decap_12
XFILLER_6_248 VGND VGND VPWR VPWR sky130_fd_sc_hd__decap_4
XFILLER_40_53 VPWR VGND VPWR VGND sky130_ef_sc_hd__decap_12
XFILLER_2_421 VGND VGND VPWR VPWR sky130_fd_sc_hd__fill_2
XFILLER_77_222 VGND VGND VPWR VPWR sky130_fd_sc_hd__fill_2
XFILLER_49_51 VGND VGND VPWR VPWR sky130_fd_sc_hd__decap_4
XFILLER_77_299 VGND VGND VPWR VPWR sky130_fd_sc_hd__decap_8
XTAP_TAPCELL_ROW_5_292 VGND VPWR sky130_fd_sc_hd__tapvpwrvgnd_1
XFILLER_1_69 VPWR VGND VPWR VGND sky130_ef_sc_hd__decap_12
XFILLER_73_461 VPWR VGND VPWR VGND sky130_ef_sc_hd__decap_12
XFILLER_41_391 VGND VGND VPWR VPWR sky130_fd_sc_hd__fill_1
X_3640_ _3640_/A _3640_/B VGND VGND VPWR VPWR _3642_/B sky130_fd_sc_hd__nand2_1
X_3571_ _3572_/A _3572_/B VGND VGND VPWR VPWR _3571_/Y sky130_fd_sc_hd__nor2_1
X_2522_ _4468_/Q _2519_/A _2534_/A2 VGND VGND VPWR VPWR _2522_/Y sky130_fd_sc_hd__o21ai_1
XFILLER_53_3 VPWR VGND VPWR VGND sky130_ef_sc_hd__decap_12
XFILLER_5_281 VGND VGND VPWR VPWR sky130_fd_sc_hd__fill_1
X_2453_ _2455_/B _2452_/Y hold244/X _2486_/B1 VGND VGND VPWR VPWR _4447_/D sky130_fd_sc_hd__a2bb2o_1
XFILLER_96_531 VGND VGND VPWR VPWR sky130_fd_sc_hd__fill_1
X_2384_ hold233/X _2414_/A2 _2414_/B1 _4549_/Q VGND VGND VPWR VPWR _4399_/D sky130_fd_sc_hd__a22o_1
X_4123_ hold239/X _4132_/A1 _4130_/S VGND VGND VPWR VPWR _4653_/D sky130_fd_sc_hd__mux2_1
XFILLER_83_203 VGND VGND VPWR VPWR sky130_fd_sc_hd__fill_1
X_4054_ _4135_/A1 hold171/X _4058_/S VGND VGND VPWR VPWR _4592_/D sky130_fd_sc_hd__mux2_1
Xinput2 ui_in[0] VGND VGND VPWR VPWR input2/X sky130_fd_sc_hd__clkbuf_1
XFILLER_83_225 VGND VGND VPWR VPWR sky130_fd_sc_hd__decap_8
XTAP_TAPCELL_ROW_67_968 VGND VPWR sky130_fd_sc_hd__tapvpwrvgnd_1
X_3005_ _4756_/Q _3006_/B VGND VGND VPWR VPWR _3007_/A sky130_fd_sc_hd__nand2_1
XTAP_TAPCELL_ROW_39_659 VGND VPWR sky130_fd_sc_hd__tapvpwrvgnd_1
XFILLER_101_15 VPWR VGND VPWR VGND sky130_ef_sc_hd__decap_12
XFILLER_52_634 VGND VGND VPWR VPWR sky130_fd_sc_hd__decap_3
XFILLER_51_188 VGND VGND VPWR VPWR sky130_fd_sc_hd__decap_4
X_3907_ _4549_/Q _3908_/B VGND VGND VPWR VPWR _3907_/Y sky130_fd_sc_hd__nor2_1
X_3838_ _3838_/A _3838_/B VGND VGND VPWR VPWR _3839_/D sky130_fd_sc_hd__and2_1
XFILLER_106_625 VPWR VGND VPWR VGND sky130_ef_sc_hd__decap_12
X_3769_ _3769_/A _3769_/B _3839_/C VGND VGND VPWR VPWR _3769_/X sky130_fd_sc_hd__or3_1
XFILLER_105_113 VPWR VGND VPWR VGND sky130_ef_sc_hd__decap_12
XFILLER_86_27 VGND VGND VPWR VPWR sky130_fd_sc_hd__fill_1
XFILLER_99_391 VGND VGND VPWR VPWR sky130_fd_sc_hd__fill_1
XFILLER_87_553 VGND VGND VPWR VPWR sky130_fd_sc_hd__decap_6
XFILLER_87_597 VPWR VGND VPWR VGND sky130_ef_sc_hd__decap_12
XFILLER_47_406 VGND VGND VPWR VPWR sky130_fd_sc_hd__fill_1
XFILLER_101_385 VGND VGND VPWR VPWR sky130_fd_sc_hd__decap_6
XFILLER_74_247 VGND VGND VPWR VPWR sky130_fd_sc_hd__decap_4
XFILLER_74_225 VGND VGND VPWR VPWR sky130_fd_sc_hd__decap_6
XTAP_TAPCELL_ROW_2_251 VGND VPWR sky130_fd_sc_hd__tapvpwrvgnd_1
XFILLER_27_174 VGND VGND VPWR VPWR sky130_fd_sc_hd__fill_2
XFILLER_70_431 VPWR VGND VPWR VGND sky130_ef_sc_hd__decap_12
XFILLER_27_196 VGND VGND VPWR VPWR sky130_fd_sc_hd__decap_8
XFILLER_11_542 VGND VGND VPWR VPWR sky130_fd_sc_hd__fill_2
XTAP_TAPCELL_ROW_90_1219 VGND VPWR sky130_fd_sc_hd__tapvpwrvgnd_1
XFILLER_97_317 VPWR VGND VPWR VGND sky130_ef_sc_hd__decap_12
XFILLER_2_251 VGND VGND VPWR VPWR sky130_fd_sc_hd__fill_1
XPHY_EDGE_ROW_29_Left_137 VGND VGND VPWR VPWR sky130_fd_sc_hd__decap_3
XFILLER_78_531 VGND VGND VPWR VPWR sky130_fd_sc_hd__fill_1
XFILLER_65_225 VPWR VGND VPWR VGND sky130_ef_sc_hd__decap_12
XTAP_TAPCELL_ROW_64_938 VGND VPWR sky130_fd_sc_hd__tapvpwrvgnd_1
XFILLER_33_111 VGND VGND VPWR VPWR sky130_fd_sc_hd__fill_1
XTAP_TAPCELL_ROW_36_629 VGND VPWR sky130_fd_sc_hd__tapvpwrvgnd_1
XFILLER_21_317 VPWR VGND VPWR VGND sky130_ef_sc_hd__decap_12
XPHY_EDGE_ROW_38_Left_146 VGND VGND VPWR VPWR sky130_fd_sc_hd__decap_3
X_4741_ clkload9/A _4741_/D fanout123/X VGND VGND VPWR VPWR _4741_/Q sky130_fd_sc_hd__dfrtp_1
X_4672_ _4676_/CLK _4672_/D fanout134/X VGND VGND VPWR VPWR _4672_/Q sky130_fd_sc_hd__dfrtp_1
X_3623_ _3573_/A _3602_/A _3603_/A VGND VGND VPWR VPWR _3623_/X sky130_fd_sc_hd__o21a_1
X_3554_ _4535_/Q _2558_/B _3553_/Y _3554_/B2 VGND VGND VPWR VPWR _4535_/D sky130_fd_sc_hd__a22o_1
XFILLER_103_617 VPWR VGND VPWR VGND sky130_ef_sc_hd__decap_12
X_3485_ _3442_/A _3525_/A _3525_/C _3484_/X VGND VGND VPWR VPWR _3486_/B sky130_fd_sc_hd__a31o_1
X_2505_ _4463_/Q _2505_/B VGND VGND VPWR VPWR _2505_/X sky130_fd_sc_hd__or2_1
XPHY_EDGE_ROW_47_Left_155 VGND VGND VPWR VPWR sky130_fd_sc_hd__decap_3
X_2436_ _2486_/A1 _2434_/X _2438_/B _2486_/B1 hold257/X VGND VGND VPWR VPWR _4442_/D
+ sky130_fd_sc_hd__a32o_1
XFILLER_69_553 VGND VGND VPWR VPWR sky130_fd_sc_hd__decap_6
XFILLER_84_501 VPWR VGND VPWR VGND sky130_ef_sc_hd__decap_12
XFILLER_69_597 VPWR VGND VPWR VGND sky130_ef_sc_hd__decap_12
X_2367_ hold20/X _2375_/A2 _2375_/B1 _4532_/Q VGND VGND VPWR VPWR _4382_/D sky130_fd_sc_hd__a22o_1
XFILLER_84_545 VPWR VGND VPWR VGND sky130_ef_sc_hd__decap_12
X_2298_ _4694_/Q _2461_/A VGND VGND VPWR VPWR _2298_/X sky130_fd_sc_hd__or2_1
X_4106_ hold94/X _4018_/X _4112_/S VGND VGND VPWR VPWR _4638_/D sky130_fd_sc_hd__mux2_1
XFILLER_56_214 VGND VGND VPWR VPWR sky130_fd_sc_hd__decap_8
XFILLER_84_589 VPWR VGND VPWR VGND sky130_ef_sc_hd__decap_12
X_4037_ _4136_/A1 hold190/X _4040_/S VGND VGND VPWR VPWR _4577_/D sky130_fd_sc_hd__mux2_1
XFILLER_72_29 VPWR VGND VPWR VGND sky130_ef_sc_hd__decap_12
XFILLER_24_133 VGND VGND VPWR VPWR sky130_fd_sc_hd__decap_6
XFILLER_52_453 VGND VGND VPWR VPWR sky130_fd_sc_hd__decap_3
XPHY_EDGE_ROW_56_Left_164 VGND VGND VPWR VPWR sky130_fd_sc_hd__decap_3
XFILLER_40_615 VGND VGND VPWR VPWR sky130_fd_sc_hd__fill_1
XFILLER_21_55 VGND VGND VPWR VPWR sky130_fd_sc_hd__fill_1
XFILLER_106_433 VPWR VGND VPWR VGND sky130_ef_sc_hd__decap_12
XPHY_EDGE_ROW_65_Left_173 VGND VGND VPWR VPWR sky130_fd_sc_hd__decap_3
XFILLER_97_15 VPWR VGND VPWR VGND sky130_ef_sc_hd__decap_12
XTAP_TAPCELL_ROW_76_1063 VGND VPWR sky130_fd_sc_hd__tapvpwrvgnd_1
XFILLER_106_477 VPWR VGND VPWR VGND sky130_ef_sc_hd__decap_12
XTAP_TAPCELL_ROW_7_310 VGND VPWR sky130_fd_sc_hd__tapvpwrvgnd_1
XFILLER_94_309 VGND VGND VPWR VPWR sky130_fd_sc_hd__decap_4
XFILLER_87_361 VGND VGND VPWR VPWR sky130_fd_sc_hd__decap_8
XFILLER_47_225 VPWR VGND VPWR VGND sky130_ef_sc_hd__decap_12
XFILLER_101_193 VPWR VGND VPWR VGND sky130_ef_sc_hd__decap_12
XPHY_EDGE_ROW_74_Left_182 VGND VGND VPWR VPWR sky130_fd_sc_hd__decap_3
XFILLER_46_41 VPWR VGND VPWR VGND sky130_ef_sc_hd__decap_12
XFILLER_47_258 VGND VGND VPWR VPWR sky130_fd_sc_hd__fill_2
XTAP_TAPCELL_ROW_87_1192 VGND VPWR sky130_fd_sc_hd__tapvpwrvgnd_1
XTAP_TAPCELL_ROW_61_908 VGND VPWR sky130_fd_sc_hd__tapvpwrvgnd_1
XFILLER_15_122 VGND VGND VPWR VPWR sky130_fd_sc_hd__fill_2
XFILLER_70_250 VGND VGND VPWR VPWR sky130_fd_sc_hd__fill_2
XFILLER_15_177 VGND VGND VPWR VPWR sky130_fd_sc_hd__decap_4
XFILLER_31_604 VGND VGND VPWR VPWR sky130_fd_sc_hd__fill_1
XFILLER_31_615 VGND VGND VPWR VPWR sky130_fd_sc_hd__fill_1
XFILLER_43_486 VGND VGND VPWR VPWR sky130_fd_sc_hd__decap_4
XTAP_TAPCELL_ROW_13_378 VGND VPWR sky130_fd_sc_hd__tapvpwrvgnd_1
XTAP_TAPCELL_ROW_41_687 VGND VPWR sky130_fd_sc_hd__tapvpwrvgnd_1
XPHY_EDGE_ROW_83_Left_191 VGND VGND VPWR VPWR sky130_fd_sc_hd__decap_3
XFILLER_7_57 VPWR VGND VPWR VGND sky130_ef_sc_hd__decap_12
XFILLER_97_125 VPWR VGND VPWR VGND sky130_ef_sc_hd__decap_12
X_3270_ _3278_/A _3270_/B VGND VGND VPWR VPWR _3274_/A sky130_fd_sc_hd__xnor2_1
X_2221_ _4765_/Q VGND VGND VPWR VPWR _2221_/Y sky130_fd_sc_hd__inv_2
XFILLER_97_169 VPWR VGND VPWR VGND sky130_ef_sc_hd__decap_12
XFILLER_87_81 VGND VGND VPWR VPWR sky130_fd_sc_hd__decap_8
XFILLER_66_501 VPWR VGND VPWR VGND sky130_ef_sc_hd__decap_12
XFILLER_66_545 VPWR VGND VPWR VGND sky130_ef_sc_hd__decap_12
XFILLER_16_3 VPWR VGND VPWR VGND sky130_ef_sc_hd__decap_12
XFILLER_38_214 VGND VGND VPWR VPWR sky130_fd_sc_hd__fill_1
XFILLER_66_589 VPWR VGND VPWR VGND sky130_ef_sc_hd__decap_12
XTAP_TAPCELL_ROW_49_776 VGND VPWR sky130_fd_sc_hd__tapvpwrvgnd_1
XFILLER_93_386 VGND VGND VPWR VPWR sky130_fd_sc_hd__decap_6
XFILLER_53_217 VGND VGND VPWR VPWR sky130_fd_sc_hd__fill_2
XFILLER_81_559 VGND VGND VPWR VPWR sky130_fd_sc_hd__fill_1
XFILLER_19_494 VGND VGND VPWR VPWR sky130_fd_sc_hd__decap_8
XFILLER_22_615 VGND VGND VPWR VPWR sky130_fd_sc_hd__fill_2
XFILLER_34_475 VGND VGND VPWR VPWR sky130_fd_sc_hd__fill_1
X_4724_ _4724_/CLK _4724_/D fanout160/X VGND VGND VPWR VPWR uo_out[5] sky130_fd_sc_hd__dfrtp_4
X_2985_ _4755_/Q _2986_/B VGND VGND VPWR VPWR _3008_/B sky130_fd_sc_hd__or2_1
X_4655_ _4737_/CLK _4655_/D fanout122/X VGND VGND VPWR VPWR hold86/A sky130_fd_sc_hd__dfrtp_1
X_4586_ _4684_/CLK _4586_/D fanout139/X VGND VGND VPWR VPWR _4586_/Q sky130_fd_sc_hd__dfrtp_1
X_3606_ _3606_/A _3606_/B _3606_/C VGND VGND VPWR VPWR _3608_/B sky130_fd_sc_hd__nand3_1
X_3537_ _3488_/Y _3492_/Y _3511_/B _3509_/Y VGND VGND VPWR VPWR _3538_/B sky130_fd_sc_hd__a31o_1
XFILLER_89_615 VGND VGND VPWR VPWR sky130_fd_sc_hd__fill_1
XFILLER_107_69 VPWR VGND VPWR VGND sky130_ef_sc_hd__decap_12
XFILLER_103_447 VGND VGND VPWR VPWR sky130_fd_sc_hd__fill_1
X_3468_ _3468_/A _3491_/A VGND VGND VPWR VPWR _3468_/X sky130_fd_sc_hd__or2_1
X_3399_ _3481_/A _3399_/B VGND VGND VPWR VPWR _3401_/A sky130_fd_sc_hd__xnor2_1
X_2419_ hold172/X _2420_/A2 _2420_/B1 _4520_/Q VGND VGND VPWR VPWR _4434_/D sky130_fd_sc_hd__a22o_1
XFILLER_29_225 VGND VGND VPWR VPWR sky130_fd_sc_hd__decap_4
XFILLER_84_397 VGND VGND VPWR VPWR sky130_fd_sc_hd__fill_2
XFILLER_83_39 VPWR VGND VPWR VGND sky130_ef_sc_hd__decap_12
XFILLER_44_239 VPWR VGND VPWR VGND sky130_ef_sc_hd__decap_12
XFILLER_13_615 VGND VGND VPWR VPWR sky130_fd_sc_hd__fill_1
XFILLER_16_77 VGND VGND VPWR VPWR sky130_fd_sc_hd__decap_6
XFILLER_80_581 VGND VGND VPWR VPWR sky130_fd_sc_hd__decap_6
XTAP_TAPCELL_ROW_10_337 VGND VPWR sky130_fd_sc_hd__tapvpwrvgnd_1
XFILLER_4_357 VGND VGND VPWR VPWR sky130_fd_sc_hd__decap_6
XFILLER_79_147 VGND VGND VPWR VPWR sky130_fd_sc_hd__decap_6
XFILLER_79_125 VGND VGND VPWR VPWR sky130_fd_sc_hd__fill_2
XFILLER_95_629 VGND VGND VPWR VPWR sky130_fd_sc_hd__decap_8
XFILLER_94_139 VGND VGND VPWR VPWR sky130_fd_sc_hd__fill_1
XTAP_TAPCELL_ROW_89_1210 VGND VPWR sky130_fd_sc_hd__tapvpwrvgnd_1
XFILLER_75_320 VPWR VGND VPWR VGND sky130_ef_sc_hd__decap_12
XFILLER_0_585 VGND VGND VPWR VPWR sky130_fd_sc_hd__decap_3
XFILLER_48_523 VGND VGND VPWR VPWR sky130_fd_sc_hd__decap_8
XFILLER_48_545 VGND VGND VPWR VPWR sky130_fd_sc_hd__fill_2
XFILLER_57_51 VGND VGND VPWR VPWR sky130_fd_sc_hd__decap_4
XFILLER_90_356 VGND VGND VPWR VPWR sky130_fd_sc_hd__decap_8
XFILLER_63_559 VGND VGND VPWR VPWR sky130_fd_sc_hd__fill_1
XTAP_TAPCELL_ROW_18_426 VGND VPWR sky130_fd_sc_hd__tapvpwrvgnd_1
XTAP_TAPCELL_ROW_46_735 VGND VPWR sky130_fd_sc_hd__tapvpwrvgnd_1
XFILLER_16_475 VGND VGND VPWR VPWR sky130_fd_sc_hd__fill_1
X_2770_ _4532_/Q _2770_/B VGND VGND VPWR VPWR _2771_/B sky130_fd_sc_hd__or2_1
Xhold107 _4674_/Q VGND VGND VPWR VPWR hold107/X sky130_fd_sc_hd__dlygate4sd3_1
X_4440_ _4706_/CLK hold1/X fanout161/X VGND VGND VPWR VPWR _4440_/Q sky130_fd_sc_hd__dfrtp_1
Xhold118 _4681_/Q VGND VGND VPWR VPWR hold118/X sky130_fd_sc_hd__dlygate4sd3_1
Xhold129 _4675_/Q VGND VGND VPWR VPWR hold129/X sky130_fd_sc_hd__dlygate4sd3_1
XFILLER_98_401 VPWR VGND VPWR VGND sky130_ef_sc_hd__decap_12
X_4371_ _4727_/CLK _4371_/D fanout150/X VGND VGND VPWR VPWR _4371_/Q sky130_fd_sc_hd__dfrtp_1
XFILLER_98_445 VPWR VGND VPWR VGND sky130_ef_sc_hd__decap_12
X_3322_ _3322_/A _3322_/B VGND VGND VPWR VPWR _3323_/B sky130_fd_sc_hd__or2_1
XFILLER_98_489 VPWR VGND VPWR VGND sky130_ef_sc_hd__decap_12
X_3253_ _3253_/A _3253_/B VGND VGND VPWR VPWR _3254_/B sky130_fd_sc_hd__xor2_1
X_3184_ _3184_/A _3184_/B VGND VGND VPWR VPWR _3185_/B sky130_fd_sc_hd__nand2_1
X_2204_ _4712_/Q VGND VGND VPWR VPWR _4250_/A sky130_fd_sc_hd__inv_2
XFILLER_81_323 VGND VGND VPWR VPWR sky130_fd_sc_hd__fill_1
XFILLER_66_397 VGND VGND VPWR VPWR sky130_fd_sc_hd__decap_3
XTAP_TAPCELL_ROW_105_1387 VGND VPWR sky130_fd_sc_hd__tapvpwrvgnd_1
XFILLER_62_581 VGND VGND VPWR VPWR sky130_fd_sc_hd__decap_6
XFILLER_22_445 VGND VGND VPWR VPWR sky130_fd_sc_hd__fill_2
X_2968_ _4536_/Q _4545_/Q VGND VGND VPWR VPWR _2970_/B sky130_fd_sc_hd__xor2_1
X_4707_ _4770_/CLK _4707_/D fanout165/X VGND VGND VPWR VPWR _4707_/Q sky130_fd_sc_hd__dfrtp_2
X_2899_ _2877_/B _2879_/B _2877_/A VGND VGND VPWR VPWR _2900_/B sky130_fd_sc_hd__a21bo_1
X_4638_ _4752_/CLK _4638_/D fanout136/X VGND VGND VPWR VPWR hold94/A sky130_fd_sc_hd__dfrtp_1
X_4569_ _4749_/CLK _4569_/D fanout127/X VGND VGND VPWR VPWR _4569_/Q sky130_fd_sc_hd__dfrtp_1
XFILLER_89_434 VPWR VGND VPWR VGND sky130_ef_sc_hd__decap_12
XTAP_TAPCELL_ROW_73_1033 VGND VPWR sky130_fd_sc_hd__tapvpwrvgnd_1
XFILLER_77_629 VGND VGND VPWR VPWR sky130_fd_sc_hd__decap_8
XFILLER_94_27 VGND VGND VPWR VPWR sky130_fd_sc_hd__fill_1
XFILLER_72_301 VGND VGND VPWR VPWR sky130_fd_sc_hd__decap_6
XTAP_TAPCELL_ROW_84_1151 VGND VPWR sky130_fd_sc_hd__tapvpwrvgnd_1
XFILLER_13_401 VGND VGND VPWR VPWR sky130_fd_sc_hd__fill_1
XTAP_TAPCELL_ROW_43_705 VGND VPWR sky130_fd_sc_hd__tapvpwrvgnd_1
XFILLER_9_405 VGND VGND VPWR VPWR sky130_fd_sc_hd__decap_8
XFILLER_40_253 VPWR VGND VPWR VGND sky130_ef_sc_hd__decap_12
XFILLER_9_449 VPWR VGND VPWR VGND sky130_ef_sc_hd__decap_12
XTAP_TAPCELL_ROW_23_484 VGND VPWR sky130_fd_sc_hd__tapvpwrvgnd_1
XTAP_TAPCELL_ROW_51_793 VGND VPWR sky130_fd_sc_hd__tapvpwrvgnd_1
XFILLER_4_121 VGND VGND VPWR VPWR sky130_fd_sc_hd__fill_1
XFILLER_107_561 VPWR VGND VPWR VGND sky130_ef_sc_hd__decap_12
XTAP_TAPCELL_ROW_95_1280 VGND VPWR sky130_fd_sc_hd__tapvpwrvgnd_1
XFILLER_68_83 VGND VGND VPWR VPWR sky130_fd_sc_hd__fill_1
XFILLER_48_342 VGND VGND VPWR VPWR sky130_fd_sc_hd__decap_4
XTAP_TAPCELL_ROW_59_882 VGND VPWR sky130_fd_sc_hd__tapvpwrvgnd_1
X_3940_ _3941_/A _3941_/B VGND VGND VPWR VPWR _3942_/A sky130_fd_sc_hd__nor2_1
X_3871_ _4762_/Q _3872_/B VGND VGND VPWR VPWR _3893_/B sky130_fd_sc_hd__or2_1
XTAP_TAPCELL_ROW_98_1309 VGND VPWR sky130_fd_sc_hd__tapvpwrvgnd_1
XFILLER_83_3 VPWR VGND VPWR VGND sky130_ef_sc_hd__decap_12
X_2822_ _2743_/B _2772_/Y _2820_/C _2821_/X VGND VGND VPWR VPWR _2822_/Y sky130_fd_sc_hd__o31ai_2
X_2753_ _2753_/A _2753_/B VGND VGND VPWR VPWR _2755_/B sky130_fd_sc_hd__xnor2_2
X_2684_ _2684_/A _2684_/B VGND VGND VPWR VPWR _2686_/B sky130_fd_sc_hd__xnor2_2
X_4423_ _4501_/CLK hold57/X fanout130/X VGND VGND VPWR VPWR hold56/A sky130_fd_sc_hd__dfrtp_1
X_4354_ hold259/X _4354_/A2 _3962_/A _4354_/B2 VGND VGND VPWR VPWR _4766_/D sky130_fd_sc_hd__a22o_1
XFILLER_98_253 VPWR VGND VPWR VGND sky130_ef_sc_hd__decap_12
XFILLER_59_629 VGND VGND VPWR VPWR sky130_fd_sc_hd__decap_8
X_3305_ _3304_/A _3304_/B _3306_/A VGND VGND VPWR VPWR _3325_/B sky130_fd_sc_hd__a21o_1
X_4285_ _4285_/A VGND VGND VPWR VPWR _4285_/Y sky130_fd_sc_hd__inv_2
XFILLER_104_15 VPWR VGND VPWR VGND sky130_ef_sc_hd__decap_12
X_3236_ hold28/A _4552_/Q VGND VGND VPWR VPWR _3237_/B sky130_fd_sc_hd__or2_1
XTAP_TAPCELL_ROW_107_1416 VGND VPWR sky130_fd_sc_hd__tapvpwrvgnd_1
XTAP_TAPCELL_ROW_107_1405 VGND VPWR sky130_fd_sc_hd__tapvpwrvgnd_1
X_3167_ _4516_/Q _3168_/B VGND VGND VPWR VPWR _3167_/X sky130_fd_sc_hd__and2_1
X_3098_ _4513_/Q _3098_/B VGND VGND VPWR VPWR _3105_/B sky130_fd_sc_hd__xor2_2
XFILLER_81_186 VGND VGND VPWR VPWR sky130_fd_sc_hd__fill_1
XFILLER_80_29 VPWR VGND VPWR VGND sky130_ef_sc_hd__decap_12
Xfanout24 _2432_/X VGND VGND VPWR VPWR _2486_/B1 sky130_fd_sc_hd__buf_2
Xfanout35 _4256_/A1 VGND VGND VPWR VPWR _4238_/A1 sky130_fd_sc_hd__clkbuf_2
Xfanout46 _2534_/A2 VGND VGND VPWR VPWR _2526_/A1 sky130_fd_sc_hd__buf_2
XFILLER_22_253 VPWR VGND VPWR VGND sky130_ef_sc_hd__decap_12
Xfanout57 fanout67/X VGND VGND VPWR VPWR _2375_/A2 sky130_fd_sc_hd__clkbuf_2
Xfanout68 _3468_/A VGND VGND VPWR VPWR _2325_/C sky130_fd_sc_hd__buf_4
Xfanout79 _2259_/X VGND VGND VPWR VPWR _3794_/B2 sky130_fd_sc_hd__clkbuf_2
XTAP_TAPCELL_ROW_20_454 VGND VPWR sky130_fd_sc_hd__tapvpwrvgnd_1
XFILLER_89_27 VPWR VGND VPWR VGND sky130_ef_sc_hd__decap_12
XFILLER_104_531 VGND VGND VPWR VPWR sky130_fd_sc_hd__fill_1
XFILLER_1_113 VGND VGND VPWR VPWR sky130_fd_sc_hd__decap_3
XFILLER_2_625 VPWR VGND VPWR VGND sky130_ef_sc_hd__decap_12
Xstream_cipher_181 VGND VGND VPWR VPWR stream_cipher_181/HI uio_out[3] sky130_fd_sc_hd__conb_1
XFILLER_49_117 VGND VGND VPWR VPWR sky130_fd_sc_hd__fill_1
XFILLER_38_53 VPWR VGND VPWR VGND sky130_ef_sc_hd__decap_12
XFILLER_38_97 VGND VGND VPWR VPWR sky130_fd_sc_hd__decap_4
XFILLER_45_345 VGND VGND VPWR VPWR sky130_fd_sc_hd__decap_6
XFILLER_57_194 VGND VGND VPWR VPWR sky130_fd_sc_hd__fill_2
XTAP_TAPCELL_ROW_28_543 VGND VPWR sky130_fd_sc_hd__tapvpwrvgnd_1
XFILLER_54_41 VPWR VGND VPWR VGND sky130_ef_sc_hd__decap_12
XTAP_TAPCELL_ROW_56_852 VGND VPWR sky130_fd_sc_hd__tapvpwrvgnd_1
XFILLER_72_197 VGND VGND VPWR VPWR sky130_fd_sc_hd__fill_2
XFILLER_60_337 VPWR VGND VPWR VGND sky130_ef_sc_hd__decap_12
XFILLER_54_85 VGND VGND VPWR VPWR sky130_fd_sc_hd__fill_1
XFILLER_13_264 VGND VGND VPWR VPWR sky130_fd_sc_hd__decap_3
XFILLER_9_257 VPWR VGND VPWR VGND sky130_ef_sc_hd__decap_12
Xclkload16 _4739_/CLK VGND VGND VPWR VPWR clkload16/X sky130_fd_sc_hd__clkbuf_8
Xclkload27 _4517_/CLK VGND VGND VPWR VPWR clkload27/Y sky130_fd_sc_hd__clkinv_4
Xclkload38 _4770_/CLK VGND VGND VPWR VPWR clkload38/Y sky130_fd_sc_hd__clkinv_2
Xclkload49 _4712_/CLK VGND VGND VPWR VPWR clkload49/Y sky130_fd_sc_hd__inv_8
XFILLER_5_474 VPWR VGND VPWR VGND sky130_ef_sc_hd__decap_12
XPHY_EDGE_ROW_10_Left_118 VGND VGND VPWR VPWR sky130_fd_sc_hd__decap_3
XFILLER_79_93 VGND VGND VPWR VPWR sky130_fd_sc_hd__decap_6
XFILLER_95_223 VGND VGND VPWR VPWR sky130_fd_sc_hd__fill_1
XFILLER_68_415 VGND VGND VPWR VPWR sky130_fd_sc_hd__decap_4
X_4070_ _4133_/A1 hold164/X _4076_/S VGND VGND VPWR VPWR _4606_/D sky130_fd_sc_hd__mux2_1
XFILLER_95_81 VPWR VGND VPWR VGND sky130_ef_sc_hd__decap_12
XFILLER_76_470 VGND VGND VPWR VPWR sky130_fd_sc_hd__decap_6
X_3021_ _3021_/A _3021_/B VGND VGND VPWR VPWR _3022_/B sky130_fd_sc_hd__nor2_1
XFILLER_48_194 VGND VGND VPWR VPWR sky130_fd_sc_hd__fill_2
XFILLER_91_473 VPWR VGND VPWR VGND sky130_ef_sc_hd__decap_12
XFILLER_63_197 VGND VGND VPWR VPWR sky130_fd_sc_hd__fill_2
XFILLER_51_337 VGND VGND VPWR VPWR sky130_fd_sc_hd__fill_1
X_3923_ _3921_/Y _3923_/B VGND VGND VPWR VPWR _3925_/A sky130_fd_sc_hd__nand2b_1
XTAP_TAPCELL_ROW_102_1357 VGND VPWR sky130_fd_sc_hd__tapvpwrvgnd_1
X_3854_ _3878_/A _3854_/B VGND VGND VPWR VPWR _3856_/C sky130_fd_sc_hd__or2_1
XFILLER_32_595 VGND VGND VPWR VPWR sky130_fd_sc_hd__fill_2
X_2805_ _4748_/Q _2805_/B VGND VGND VPWR VPWR _2806_/B sky130_fd_sc_hd__or2_1
X_3785_ _3785_/A _3785_/B VGND VGND VPWR VPWR _3785_/X sky130_fd_sc_hd__or2_1
X_2736_ hold297/X _2983_/A2 _3529_/A _4339_/B2 VGND VGND VPWR VPWR _4498_/D sky130_fd_sc_hd__a22o_1
XFILLER_105_317 VPWR VGND VPWR VGND sky130_ef_sc_hd__decap_12
X_2667_ _2667_/A _2667_/B VGND VGND VPWR VPWR _3451_/A sky130_fd_sc_hd__xnor2_4
X_4406_ _4734_/CLK _4406_/D fanout146/X VGND VGND VPWR VPWR _4406_/Q sky130_fd_sc_hd__dfrtp_1
XFILLER_99_573 VPWR VGND VPWR VGND sky130_ef_sc_hd__decap_12
XTAP_TAPCELL_ROW_70_1003 VGND VPWR sky130_fd_sc_hd__tapvpwrvgnd_1
X_2598_ _2598_/A _2598_/B VGND VGND VPWR VPWR _2600_/A sky130_fd_sc_hd__nand2_1
X_4337_ _4749_/Q _4339_/A2 _3546_/A _4339_/B2 VGND VGND VPWR VPWR _4749_/D sky130_fd_sc_hd__a22o_1
X_4268_ _4372_/Q hold35/A hold17/A hold63/A _2427_/A _2249_/B VGND VGND VPWR VPWR
+ _4269_/B sky130_fd_sc_hd__mux4_1
X_3219_ _4765_/Q _3219_/B VGND VGND VPWR VPWR _3220_/B sky130_fd_sc_hd__or2_1
XFILLER_86_289 VPWR VGND VPWR VGND sky130_ef_sc_hd__decap_12
XFILLER_67_481 VPWR VGND VPWR VGND sky130_ef_sc_hd__decap_12
X_4199_ _4697_/Q _4197_/B _4198_/X VGND VGND VPWR VPWR _4697_/D sky130_fd_sc_hd__o21a_1
XFILLER_91_39 VPWR VGND VPWR VGND sky130_ef_sc_hd__decap_12
XFILLER_70_613 VPWR VGND VPWR VGND sky130_ef_sc_hd__decap_12
XTAP_TAPCELL_ROW_25_502 VGND VPWR sky130_fd_sc_hd__tapvpwrvgnd_1
XTAP_TAPCELL_ROW_53_811 VGND VPWR sky130_fd_sc_hd__tapvpwrvgnd_1
XFILLER_54_197 VPWR VGND VPWR VGND sky130_ef_sc_hd__decap_12
XTAP_TAPCELL_ROW_81_1121 VGND VPWR sky130_fd_sc_hd__tapvpwrvgnd_1
XFILLER_42_359 VGND VGND VPWR VPWR sky130_fd_sc_hd__decap_4
XFILLER_24_77 VGND VGND VPWR VPWR sky130_fd_sc_hd__decap_6
XTAP_TAPCELL_ROW_33_590 VGND VPWR sky130_fd_sc_hd__tapvpwrvgnd_1
XFILLER_10_245 VGND VGND VPWR VPWR sky130_fd_sc_hd__decap_6
XFILLER_40_65 VGND VGND VPWR VPWR sky130_fd_sc_hd__decap_8
XFILLER_2_411 VGND VGND VPWR VPWR sky130_fd_sc_hd__fill_1
Xhold290 _4521_/Q VGND VGND VPWR VPWR hold290/X sky130_fd_sc_hd__dlygate4sd3_1
XFILLER_77_289 VGND VGND VPWR VPWR sky130_fd_sc_hd__decap_3
XFILLER_77_278 VGND VGND VPWR VPWR sky130_fd_sc_hd__fill_2
XTAP_TAPCELL_ROW_5_282 VGND VPWR sky130_fd_sc_hd__tapvpwrvgnd_1
XFILLER_1_15 VPWR VGND VPWR VGND sky130_ef_sc_hd__decap_12
XFILLER_18_301 VGND VGND VPWR VPWR sky130_fd_sc_hd__fill_1
XFILLER_92_226 VGND VGND VPWR VPWR sky130_fd_sc_hd__decap_4
XFILLER_65_51 VGND VGND VPWR VPWR sky130_fd_sc_hd__decap_4
XFILLER_45_120 VGND VGND VPWR VPWR sky130_fd_sc_hd__decap_8
XFILLER_73_473 VPWR VGND VPWR VGND sky130_ef_sc_hd__decap_12
XFILLER_33_315 VGND VGND VPWR VPWR sky130_fd_sc_hd__decap_3
XFILLER_33_326 VGND VGND VPWR VPWR sky130_fd_sc_hd__decap_8
XFILLER_45_175 VGND VGND VPWR VPWR sky130_fd_sc_hd__fill_1
XFILLER_60_101 VGND VGND VPWR VPWR sky130_fd_sc_hd__fill_1
XFILLER_33_348 VGND VGND VPWR VPWR sky130_fd_sc_hd__fill_1
XFILLER_60_123 VGND VGND VPWR VPWR sky130_fd_sc_hd__decap_4
X_3570_ _3572_/A _3572_/B VGND VGND VPWR VPWR _3573_/A sky130_fd_sc_hd__nand2_1
X_2521_ _2521_/A _2521_/B VGND VGND VPWR VPWR _2525_/B sky130_fd_sc_hd__nor2_1
XFILLER_5_260 VPWR VGND VPWR VGND sky130_ef_sc_hd__decap_12
XFILLER_102_309 VPWR VGND VPWR VGND sky130_ef_sc_hd__decap_12
X_2452_ _4447_/Q _2448_/A _2486_/A1 VGND VGND VPWR VPWR _2452_/Y sky130_fd_sc_hd__o21ai_1
XFILLER_46_3 VPWR VGND VPWR VGND sky130_ef_sc_hd__decap_12
XFILLER_68_212 VPWR VGND VPWR VGND sky130_ef_sc_hd__decap_12
X_2383_ _4398_/Q _2414_/A2 _2414_/B1 hold28/X VGND VGND VPWR VPWR hold29/A sky130_fd_sc_hd__a22o_1
XPHY_EDGE_ROW_18_Right_18 VGND VGND VPWR VPWR sky130_fd_sc_hd__decap_3
X_4122_ _4131_/D _4140_/B _4131_/B _4140_/D VGND VGND VPWR VPWR _4130_/S sky130_fd_sc_hd__and4bb_4
XFILLER_96_587 VGND VGND VPWR VPWR sky130_fd_sc_hd__fill_1
X_4053_ _4134_/A1 hold193/X _4058_/S VGND VGND VPWR VPWR _4591_/D sky130_fd_sc_hd__mux2_1
X_3004_ _4577_/Q _4609_/Q _4641_/Q _4673_/Q _4324_/S _3174_/S1 VGND VGND VPWR VPWR
+ _3006_/B sky130_fd_sc_hd__mux4_1
Xinput3 ui_in[1] VGND VGND VPWR VPWR input3/X sky130_fd_sc_hd__clkbuf_1
XFILLER_36_120 VGND VGND VPWR VPWR sky130_fd_sc_hd__decap_4
XFILLER_49_481 VPWR VGND VPWR VGND sky130_ef_sc_hd__decap_12
XTAP_TAPCELL_ROW_67_969 VGND VPWR sky130_fd_sc_hd__tapvpwrvgnd_1
XFILLER_91_281 VPWR VGND VPWR VGND sky130_ef_sc_hd__decap_12
XFILLER_101_27 VPWR VGND VPWR VGND sky130_ef_sc_hd__decap_12
XPHY_EDGE_ROW_27_Right_27 VGND VGND VPWR VPWR sky130_fd_sc_hd__decap_3
XFILLER_36_197 VGND VGND VPWR VPWR sky130_fd_sc_hd__decap_8
X_3906_ _3906_/A _3906_/B VGND VGND VPWR VPWR _3908_/B sky130_fd_sc_hd__xnor2_2
XFILLER_51_178 VGND VGND VPWR VPWR sky130_fd_sc_hd__decap_3
XFILLER_20_510 VGND VGND VPWR VPWR sky130_fd_sc_hd__fill_2
X_3837_ _3847_/A _3837_/B VGND VGND VPWR VPWR _3843_/A sky130_fd_sc_hd__nor2_1
X_3768_ _3769_/A _3769_/B _3839_/C VGND VGND VPWR VPWR _3768_/Y sky130_fd_sc_hd__o21ai_1
XTAP_TAPCELL_ROW_30_560 VGND VPWR sky130_fd_sc_hd__tapvpwrvgnd_1
X_2719_ _2720_/A _2720_/B _2808_/A VGND VGND VPWR VPWR _2721_/A sky130_fd_sc_hd__a21oi_1
XFILLER_105_125 VPWR VGND VPWR VGND sky130_ef_sc_hd__decap_12
X_3699_ _3699_/A _3735_/B VGND VGND VPWR VPWR _3732_/C sky130_fd_sc_hd__nand2_1
XFILLER_105_169 VPWR VGND VPWR VGND sky130_ef_sc_hd__decap_12
XPHY_EDGE_ROW_36_Right_36 VGND VGND VPWR VPWR sky130_fd_sc_hd__decap_3
XFILLER_19_55 VGND VGND VPWR VPWR sky130_fd_sc_hd__fill_1
XFILLER_19_109 VGND VGND VPWR VPWR sky130_fd_sc_hd__decap_3
XFILLER_59_289 VGND VGND VPWR VPWR sky130_fd_sc_hd__fill_1
XFILLER_74_237 VGND VGND VPWR VPWR sky130_fd_sc_hd__decap_3
XTAP_TAPCELL_ROW_2_252 VGND VPWR sky130_fd_sc_hd__tapvpwrvgnd_1
XFILLER_82_281 VGND VGND VPWR VPWR sky130_fd_sc_hd__decap_6
XFILLER_15_304 VPWR VGND VPWR VGND sky130_ef_sc_hd__decap_12
XFILLER_43_613 VGND VGND VPWR VPWR sky130_fd_sc_hd__decap_3
XPHY_EDGE_ROW_45_Right_45 VGND VGND VPWR VPWR sky130_fd_sc_hd__decap_3
XFILLER_70_443 VPWR VGND VPWR VGND sky130_ef_sc_hd__decap_12
XFILLER_15_337 VGND VGND VPWR VPWR sky130_fd_sc_hd__decap_4
XFILLER_70_465 VGND VGND VPWR VPWR sky130_fd_sc_hd__decap_8
XFILLER_30_307 VGND VGND VPWR VPWR sky130_fd_sc_hd__fill_1
XFILLER_7_503 VGND VGND VPWR VPWR sky130_fd_sc_hd__fill_1
XPHY_EDGE_ROW_54_Right_54 VGND VGND VPWR VPWR sky130_fd_sc_hd__decap_3
XFILLER_2_241 VGND VGND VPWR VPWR sky130_fd_sc_hd__decap_4
XFILLER_97_329 VGND VGND VPWR VPWR sky130_fd_sc_hd__decap_6
XFILLER_78_587 VGND VGND VPWR VPWR sky130_fd_sc_hd__fill_1
XFILLER_38_429 VGND VGND VPWR VPWR sky130_fd_sc_hd__fill_1
XFILLER_65_237 VGND VGND VPWR VPWR sky130_fd_sc_hd__decap_6
XPHY_EDGE_ROW_63_Right_63 VGND VGND VPWR VPWR sky130_fd_sc_hd__decap_3
XTAP_TAPCELL_ROW_64_939 VGND VPWR sky130_fd_sc_hd__tapvpwrvgnd_1
XFILLER_61_421 VGND VGND VPWR VPWR sky130_fd_sc_hd__decap_4
X_4740_ _4740_/CLK _4740_/D fanout123/X VGND VGND VPWR VPWR _4740_/Q sky130_fd_sc_hd__dfrtp_1
X_4671_ _4671_/CLK _4671_/D fanout135/X VGND VGND VPWR VPWR _4671_/Q sky130_fd_sc_hd__dfrtp_1
X_3622_ _3571_/Y _3602_/A _3603_/A VGND VGND VPWR VPWR _3622_/X sky130_fd_sc_hd__o21a_1
XPHY_EDGE_ROW_72_Right_72 VGND VGND VPWR VPWR sky130_fd_sc_hd__decap_3
X_3553_ _3585_/B _3553_/B VGND VGND VPWR VPWR _3553_/Y sky130_fd_sc_hd__xnor2_1
X_3484_ _3441_/A _3525_/C _3525_/B VGND VGND VPWR VPWR _3484_/X sky130_fd_sc_hd__a21bo_1
X_2504_ _4463_/Q _2505_/B VGND VGND VPWR VPWR _2509_/B sky130_fd_sc_hd__nand2_1
XFILLER_103_629 VGND VGND VPWR VPWR sky130_fd_sc_hd__decap_8
XPHY_EDGE_ROW_102_Left_210 VGND VGND VPWR VPWR sky130_fd_sc_hd__decap_3
XFILLER_88_318 VPWR VGND VPWR VGND sky130_ef_sc_hd__decap_12
X_2435_ _4441_/Q _4442_/Q VGND VGND VPWR VPWR _2438_/B sky130_fd_sc_hd__nand2_1
XFILLER_102_139 VGND VGND VPWR VPWR sky130_fd_sc_hd__fill_1
XFILLER_84_513 VPWR VGND VPWR VGND sky130_ef_sc_hd__decap_12
X_2366_ hold30/X _2395_/A2 _2395_/B1 _4531_/Q VGND VGND VPWR VPWR _4381_/D sky130_fd_sc_hd__a22o_1
X_4105_ hold112/X _4008_/X _4112_/S VGND VGND VPWR VPWR _4637_/D sky130_fd_sc_hd__mux2_1
XPHY_EDGE_ROW_81_Right_81 VGND VGND VPWR VPWR sky130_fd_sc_hd__decap_3
X_2297_ _4692_/Q _2185_/Y _4691_/Q _2451_/A _2296_/X VGND VGND VPWR VPWR _2297_/X
+ sky130_fd_sc_hd__a221o_1
XFILLER_84_557 VPWR VGND VPWR VGND sky130_ef_sc_hd__decap_12
X_4036_ _4135_/A1 hold138/X _4040_/S VGND VGND VPWR VPWR _4576_/D sky130_fd_sc_hd__mux2_1
XFILLER_52_421 VPWR VGND VPWR VGND sky130_ef_sc_hd__decap_12
XFILLER_24_178 VPWR VGND VPWR VGND sky130_ef_sc_hd__decap_12
XPHY_EDGE_ROW_90_Right_90 VGND VGND VPWR VPWR sky130_fd_sc_hd__decap_3
XFILLER_106_401 VPWR VGND VPWR VGND sky130_ef_sc_hd__decap_12
XFILLER_106_445 VPWR VGND VPWR VGND sky130_ef_sc_hd__decap_12
XFILLER_97_27 VPWR VGND VPWR VGND sky130_ef_sc_hd__decap_12
XTAP_TAPCELL_ROW_76_1064 VGND VPWR sky130_fd_sc_hd__tapvpwrvgnd_1
XFILLER_106_489 VPWR VGND VPWR VGND sky130_ef_sc_hd__decap_12
XTAP_TAPCELL_ROW_7_311 VGND VPWR sky130_fd_sc_hd__tapvpwrvgnd_1
XFILLER_101_161 VGND VGND VPWR VPWR sky130_fd_sc_hd__decap_6
XFILLER_47_237 VPWR VGND VPWR VGND sky130_ef_sc_hd__decap_12
XFILLER_46_53 VPWR VGND VPWR VGND sky130_ef_sc_hd__decap_12
XTAP_TAPCELL_ROW_87_1193 VGND VPWR sky130_fd_sc_hd__tapvpwrvgnd_1
XFILLER_16_635 VGND VGND VPWR VPWR sky130_fd_sc_hd__fill_2
XFILLER_55_281 VGND VGND VPWR VPWR sky130_fd_sc_hd__decap_8
XFILLER_43_476 VGND VGND VPWR VPWR sky130_fd_sc_hd__fill_2
XFILLER_62_41 VPWR VGND VPWR VGND sky130_ef_sc_hd__decap_12
XFILLER_62_85 VGND VGND VPWR VPWR sky130_fd_sc_hd__decap_4
XTAP_TAPCELL_ROW_13_379 VGND VPWR sky130_fd_sc_hd__tapvpwrvgnd_1
XTAP_TAPCELL_ROW_41_688 VGND VPWR sky130_fd_sc_hd__tapvpwrvgnd_1
XFILLER_7_69 VPWR VGND VPWR VGND sky130_ef_sc_hd__decap_12
XFILLER_7_388 VGND VGND VPWR VPWR sky130_fd_sc_hd__decap_4
XFILLER_3_561 VGND VGND VPWR VPWR sky130_fd_sc_hd__decap_8
XFILLER_97_137 VPWR VGND VPWR VGND sky130_ef_sc_hd__decap_12
X_2220_ _4760_/Q VGND VGND VPWR VPWR _3814_/A sky130_fd_sc_hd__inv_2
XFILLER_66_513 VPWR VGND VPWR VGND sky130_ef_sc_hd__decap_12
XFILLER_81_505 VPWR VGND VPWR VGND sky130_ef_sc_hd__decap_12
XFILLER_66_557 VPWR VGND VPWR VGND sky130_ef_sc_hd__decap_12
XFILLER_38_259 VGND VGND VPWR VPWR sky130_fd_sc_hd__fill_2
XTAP_TAPCELL_ROW_49_766 VGND VPWR sky130_fd_sc_hd__tapvpwrvgnd_1
XFILLER_34_410 VGND VGND VPWR VPWR sky130_fd_sc_hd__fill_2
XFILLER_34_421 VGND VGND VPWR VPWR sky130_fd_sc_hd__fill_1
XFILLER_61_295 VGND VGND VPWR VPWR sky130_fd_sc_hd__decap_8
X_2984_ _4576_/Q _4608_/Q _4640_/Q _4672_/Q _4324_/S _3174_/S1 VGND VGND VPWR VPWR
+ _2986_/B sky130_fd_sc_hd__mux4_1
X_4723_ _4735_/CLK _4723_/D fanout149/X VGND VGND VPWR VPWR uo_out[4] sky130_fd_sc_hd__dfrtp_4
XFILLER_107_209 VGND VGND VPWR VPWR sky130_fd_sc_hd__decap_3
X_4654_ _4737_/CLK _4654_/D fanout122/X VGND VGND VPWR VPWR _4654_/Q sky130_fd_sc_hd__dfrtp_1
X_4585_ _4764_/CLK _4585_/D fanout141/X VGND VGND VPWR VPWR _4585_/Q sky130_fd_sc_hd__dfrtp_1
X_3605_ _3605_/A _3605_/B VGND VGND VPWR VPWR _3606_/C sky130_fd_sc_hd__xnor2_1
X_3536_ _3536_/A _3536_/B VGND VGND VPWR VPWR _3538_/A sky130_fd_sc_hd__xnor2_1
XFILLER_107_15 VPWR VGND VPWR VGND sky130_ef_sc_hd__decap_12
X_3467_ _3467_/A _3467_/B VGND VGND VPWR VPWR _3491_/A sky130_fd_sc_hd__nor2_1
X_3398_ _3481_/A _3399_/B VGND VGND VPWR VPWR _3398_/X sky130_fd_sc_hd__or2_1
XFILLER_57_502 VGND VGND VPWR VPWR sky130_fd_sc_hd__fill_2
X_2418_ hold176/X _2420_/A2 _2420_/B1 _4519_/Q VGND VGND VPWR VPWR _4433_/D sky130_fd_sc_hd__a22o_1
X_2349_ _2347_/X _2349_/B VGND VGND VPWR VPWR _4362_/D sky130_fd_sc_hd__and2b_1
XFILLER_84_365 VGND VGND VPWR VPWR sky130_fd_sc_hd__decap_8
X_4019_ _4095_/B _4016_/B _4133_/A1 _4016_/Y hold92/X VGND VGND VPWR VPWR _4566_/D
+ sky130_fd_sc_hd__a32o_1
XFILLER_37_281 VPWR VGND VPWR VGND sky130_ef_sc_hd__decap_12
XPHY_EDGE_ROW_0_Right_0 VGND VGND VPWR VPWR sky130_fd_sc_hd__decap_3
XFILLER_25_465 VGND VGND VPWR VPWR sky130_fd_sc_hd__decap_3
XFILLER_52_262 VGND VGND VPWR VPWR sky130_fd_sc_hd__decap_6
XFILLER_40_435 VGND VGND VPWR VPWR sky130_fd_sc_hd__fill_2
XFILLER_8_119 VGND VGND VPWR VPWR sky130_fd_sc_hd__fill_1
XTAP_TAPCELL_ROW_10_338 VGND VPWR sky130_fd_sc_hd__tapvpwrvgnd_1
XFILLER_106_253 VPWR VGND VPWR VGND sky130_ef_sc_hd__decap_12
XFILLER_0_531 VGND VGND VPWR VPWR sky130_fd_sc_hd__fill_1
XTAP_TAPCELL_ROW_89_1211 VGND VPWR sky130_fd_sc_hd__tapvpwrvgnd_1
XFILLER_75_332 VGND VGND VPWR VPWR sky130_fd_sc_hd__decap_4
XFILLER_63_505 VPWR VGND VPWR VGND sky130_ef_sc_hd__decap_12
XFILLER_90_346 VGND VGND VPWR VPWR sky130_fd_sc_hd__decap_6
XFILLER_16_421 VGND VGND VPWR VPWR sky130_fd_sc_hd__decap_3
XTAP_TAPCELL_ROW_18_427 VGND VPWR sky130_fd_sc_hd__tapvpwrvgnd_1
XTAP_TAPCELL_ROW_46_736 VGND VPWR sky130_fd_sc_hd__tapvpwrvgnd_1
XFILLER_73_51 VGND VGND VPWR VPWR sky130_fd_sc_hd__decap_4
XFILLER_43_273 VGND VGND VPWR VPWR sky130_fd_sc_hd__fill_1
XFILLER_31_457 VGND VGND VPWR VPWR sky130_fd_sc_hd__fill_2
Xhold108 _4669_/Q VGND VGND VPWR VPWR hold108/X sky130_fd_sc_hd__dlygate4sd3_1
Xhold119 _4559_/Q VGND VGND VPWR VPWR hold119/X sky130_fd_sc_hd__dlygate4sd3_1
X_4370_ _4706_/CLK _4370_/D fanout161/X VGND VGND VPWR VPWR _4370_/Q sky130_fd_sc_hd__dfrtp_1
XFILLER_98_413 VGND VGND VPWR VPWR sky130_fd_sc_hd__decap_6
X_3321_ _3322_/A _3322_/B VGND VGND VPWR VPWR _3346_/A sky130_fd_sc_hd__nand2_1
XFILLER_98_457 VPWR VGND VPWR VGND sky130_ef_sc_hd__decap_12
X_3252_ _3237_/B _3239_/B _3237_/A VGND VGND VPWR VPWR _3253_/B sky130_fd_sc_hd__a21bo_1
XFILLER_3_391 VGND VGND VPWR VPWR sky130_fd_sc_hd__fill_1
X_3183_ _4545_/Q _4549_/Q VGND VGND VPWR VPWR _3184_/B sky130_fd_sc_hd__or2_1
XFILLER_66_321 VGND VGND VPWR VPWR sky130_fd_sc_hd__fill_2
XFILLER_39_513 VGND VGND VPWR VPWR sky130_fd_sc_hd__decap_4
XFILLER_39_524 VGND VGND VPWR VPWR sky130_fd_sc_hd__decap_4
X_2203_ _4469_/Q VGND VGND VPWR VPWR _2203_/Y sky130_fd_sc_hd__inv_2
XFILLER_93_162 VGND VGND VPWR VPWR sky130_fd_sc_hd__decap_6
XFILLER_81_335 VGND VGND VPWR VPWR sky130_fd_sc_hd__fill_1
XTAP_TAPCELL_ROW_105_1388 VGND VPWR sky130_fd_sc_hd__tapvpwrvgnd_1
XFILLER_34_295 VGND VGND VPWR VPWR sky130_fd_sc_hd__fill_1
X_2967_ _3009_/A _2967_/B VGND VGND VPWR VPWR _2975_/A sky130_fd_sc_hd__xnor2_1
X_4706_ _4706_/CLK _4706_/D fanout164/X VGND VGND VPWR VPWR _4706_/Q sky130_fd_sc_hd__dfrtp_1
X_2898_ _2898_/A _2898_/B VGND VGND VPWR VPWR _2900_/A sky130_fd_sc_hd__nand2_2
X_4637_ _4752_/CLK _4637_/D fanout133/X VGND VGND VPWR VPWR _4637_/Q sky130_fd_sc_hd__dfrtp_1
XFILLER_78_29 VPWR VGND VPWR VGND sky130_ef_sc_hd__decap_12
X_4568_ _4667_/CLK _4568_/D fanout124/X VGND VGND VPWR VPWR hold69/A sky130_fd_sc_hd__dfrtp_1
XFILLER_103_223 VGND VGND VPWR VPWR sky130_fd_sc_hd__fill_1
XFILLER_89_446 VGND VGND VPWR VPWR sky130_fd_sc_hd__fill_2
XTAP_TAPCELL_ROW_73_1034 VGND VPWR sky130_fd_sc_hd__tapvpwrvgnd_1
X_4499_ _4499_/CLK _4499_/D fanout132/X VGND VGND VPWR VPWR _4499_/Q sky130_fd_sc_hd__dfrtp_4
X_3519_ hold72/A _4665_/Q _3519_/S VGND VGND VPWR VPWR _3520_/B sky130_fd_sc_hd__mux2_1
XFILLER_72_335 VGND VGND VPWR VPWR sky130_fd_sc_hd__decap_4
XFILLER_27_55 VGND VGND VPWR VPWR sky130_fd_sc_hd__fill_1
XTAP_TAPCELL_ROW_84_1152 VGND VPWR sky130_fd_sc_hd__tapvpwrvgnd_1
XTAP_TAPCELL_ROW_43_706 VGND VPWR sky130_fd_sc_hd__tapvpwrvgnd_1
XFILLER_53_593 VGND VGND VPWR VPWR sky130_fd_sc_hd__decap_3
XFILLER_40_265 VPWR VGND VPWR VGND sky130_ef_sc_hd__decap_12
Xclkbuf_leaf_20_clk clkload3/A VGND VGND VPWR VPWR _4513_/CLK sky130_fd_sc_hd__clkbuf_8
XTAP_TAPCELL_ROW_23_485 VGND VPWR sky130_fd_sc_hd__tapvpwrvgnd_1
XTAP_TAPCELL_ROW_51_794 VGND VPWR sky130_fd_sc_hd__tapvpwrvgnd_1
XFILLER_5_612 VGND VGND VPWR VPWR sky130_fd_sc_hd__decap_4
XFILLER_107_573 VPWR VGND VPWR VGND sky130_ef_sc_hd__decap_12
XTAP_TAPCELL_ROW_95_1281 VGND VPWR sky130_fd_sc_hd__tapvpwrvgnd_1
XFILLER_4_144 VPWR VGND VPWR VGND sky130_ef_sc_hd__decap_12
XFILLER_4_15 VPWR VGND VPWR VGND sky130_ef_sc_hd__decap_12
XFILLER_4_177 VGND VGND VPWR VPWR sky130_fd_sc_hd__decap_8
XFILLER_95_405 VPWR VGND VPWR VGND sky130_ef_sc_hd__decap_12
XFILLER_95_449 VPWR VGND VPWR VGND sky130_ef_sc_hd__decap_12
XFILLER_0_361 VGND VGND VPWR VPWR sky130_fd_sc_hd__decap_3
XFILLER_0_383 VGND VGND VPWR VPWR sky130_fd_sc_hd__decap_4
XTAP_TAPCELL_ROW_59_883 VGND VPWR sky130_fd_sc_hd__tapvpwrvgnd_1
XFILLER_63_379 VPWR VGND VPWR VGND sky130_ef_sc_hd__decap_12
XFILLER_16_251 VGND VGND VPWR VPWR sky130_fd_sc_hd__fill_1
X_3870_ _4547_/Q _3979_/B2 _3869_/Y _3978_/A VGND VGND VPWR VPWR _4547_/D sky130_fd_sc_hd__a22o_1
X_2821_ _2771_/A _2795_/A _2795_/B VGND VGND VPWR VPWR _2821_/X sky130_fd_sc_hd__a21bo_1
XFILLER_31_254 VGND VGND VPWR VPWR sky130_fd_sc_hd__decap_6
XFILLER_76_3 VPWR VGND VPWR VGND sky130_ef_sc_hd__decap_12
Xclkbuf_leaf_11_clk clkload2/A VGND VGND VPWR VPWR _4756_/CLK sky130_fd_sc_hd__clkbuf_8
X_2752_ _2752_/A _2808_/B VGND VGND VPWR VPWR _2753_/B sky130_fd_sc_hd__xor2_1
X_2683_ _2683_/A _2683_/B VGND VGND VPWR VPWR _2684_/B sky130_fd_sc_hd__xor2_2
X_4422_ _4504_/CLK _4422_/D fanout130/X VGND VGND VPWR VPWR _4422_/Q sky130_fd_sc_hd__dfrtp_1
XFILLER_98_221 VPWR VGND VPWR VGND sky130_ef_sc_hd__decap_12
X_4353_ _4765_/Q _4354_/A2 _3941_/A _4354_/B2 VGND VGND VPWR VPWR _4765_/D sky130_fd_sc_hd__a22o_1
XFILLER_98_265 VPWR VGND VPWR VGND sky130_ef_sc_hd__decap_12
X_3304_ _3304_/A _3304_/B VGND VGND VPWR VPWR _3306_/B sky130_fd_sc_hd__and2_1
X_4284_ _4406_/Q hold49/A _4422_/Q _4430_/Q _4319_/S0 _2249_/B VGND VGND VPWR VPWR
+ _4285_/A sky130_fd_sc_hd__mux4_1
X_3235_ hold28/A _4552_/Q VGND VGND VPWR VPWR _3237_/A sky130_fd_sc_hd__nand2_1
XFILLER_104_27 VGND VGND VPWR VPWR sky130_fd_sc_hd__fill_1
XTAP_TAPCELL_ROW_107_1406 VGND VPWR sky130_fd_sc_hd__tapvpwrvgnd_1
X_3166_ _3166_/A _3166_/B VGND VGND VPWR VPWR _3168_/B sky130_fd_sc_hd__xnor2_1
XFILLER_27_505 VGND VGND VPWR VPWR sky130_fd_sc_hd__decap_3
XTAP_TAPCELL_ROW_107_1417 VGND VPWR sky130_fd_sc_hd__tapvpwrvgnd_1
X_3097_ _4513_/Q _3098_/B VGND VGND VPWR VPWR _3097_/X sky130_fd_sc_hd__or2_1
Xfanout14 _3267_/Y VGND VGND VPWR VPWR _3569_/S0 sky130_fd_sc_hd__buf_4
Xfanout25 _2432_/X VGND VGND VPWR VPWR _2483_/B2 sky130_fd_sc_hd__clkbuf_2
Xfanout36 _2407_/B1 VGND VGND VPWR VPWR _2379_/B1 sky130_fd_sc_hd__buf_2
Xfanout47 _2261_/X VGND VGND VPWR VPWR _2534_/A2 sky130_fd_sc_hd__clkbuf_2
XFILLER_50_530 VGND VGND VPWR VPWR sky130_fd_sc_hd__fill_2
XFILLER_50_541 VPWR VGND VPWR VGND sky130_ef_sc_hd__decap_12
XFILLER_10_405 VGND VGND VPWR VPWR sky130_fd_sc_hd__fill_1
X_3999_ _4095_/A _4030_/B VGND VGND VPWR VPWR _4007_/S sky130_fd_sc_hd__nor2_4
XFILLER_22_265 VGND VGND VPWR VPWR sky130_fd_sc_hd__decap_6
Xfanout58 fanout67/X VGND VGND VPWR VPWR _2395_/A2 sky130_fd_sc_hd__buf_2
Xfanout69 _3845_/A VGND VGND VPWR VPWR _3468_/A sky130_fd_sc_hd__buf_4
XFILLER_13_57 VPWR VGND VPWR VGND sky130_ef_sc_hd__decap_12
XTAP_TAPCELL_ROW_20_455 VGND VPWR sky130_fd_sc_hd__tapvpwrvgnd_1
XFILLER_89_39 VPWR VGND VPWR VGND sky130_ef_sc_hd__decap_12
XFILLER_77_405 VGND VGND VPWR VPWR sky130_fd_sc_hd__decap_6
Xstream_cipher_182 VGND VGND VPWR VPWR stream_cipher_182/HI uio_out[4] sky130_fd_sc_hd__conb_1
XFILLER_104_587 VGND VGND VPWR VPWR sky130_fd_sc_hd__fill_1
XFILLER_1_169 VGND VGND VPWR VPWR sky130_fd_sc_hd__fill_2
XFILLER_77_449 VPWR VGND VPWR VGND sky130_ef_sc_hd__decap_12
XFILLER_38_65 VPWR VGND VPWR VGND sky130_ef_sc_hd__decap_12
XFILLER_45_302 VGND VGND VPWR VPWR sky130_fd_sc_hd__decap_6
XTAP_TAPCELL_ROW_28_544 VGND VPWR sky130_fd_sc_hd__tapvpwrvgnd_1
XTAP_TAPCELL_ROW_56_853 VGND VPWR sky130_fd_sc_hd__tapvpwrvgnd_1
XFILLER_54_53 VGND VGND VPWR VPWR sky130_fd_sc_hd__decap_8
XFILLER_13_232 VGND VGND VPWR VPWR sky130_fd_sc_hd__decap_6
XFILLER_41_541 VGND VGND VPWR VPWR sky130_fd_sc_hd__decap_8
XFILLER_54_97 VGND VGND VPWR VPWR sky130_fd_sc_hd__fill_1
XFILLER_60_349 VGND VGND VPWR VPWR sky130_fd_sc_hd__decap_4
XFILLER_70_41 VPWR VGND VPWR VGND sky130_ef_sc_hd__decap_12
XFILLER_70_85 VPWR VGND VPWR VGND sky130_ef_sc_hd__decap_12
Xclkload17 _4757_/CLK VGND VGND VPWR VPWR clkload17/Y sky130_fd_sc_hd__inv_8
Xclkload39 _4708_/CLK VGND VGND VPWR VPWR clkload39/X sky130_fd_sc_hd__clkbuf_4
Xclkload28 _4539_/CLK VGND VGND VPWR VPWR clkload28/X sky130_fd_sc_hd__clkbuf_8
XFILLER_5_486 VPWR VGND VPWR VGND sky130_ef_sc_hd__decap_12
XFILLER_68_449 VPWR VGND VPWR VGND sky130_ef_sc_hd__decap_12
XFILLER_95_279 VGND VGND VPWR VPWR sky130_fd_sc_hd__fill_1
XFILLER_95_93 VPWR VGND VPWR VGND sky130_ef_sc_hd__decap_12
XFILLER_83_408 VGND VGND VPWR VPWR sky130_fd_sc_hd__decap_6
X_3020_ _4542_/Q _3020_/B VGND VGND VPWR VPWR _3021_/B sky130_fd_sc_hd__nor2_1
Xclkbuf_leaf_0_clk clkload0/A VGND VGND VPWR VPWR _4661_/CLK sky130_fd_sc_hd__clkbuf_8
XFILLER_48_162 VGND VGND VPWR VPWR sky130_fd_sc_hd__decap_4
XFILLER_91_441 VGND VGND VPWR VPWR sky130_fd_sc_hd__decap_6
XFILLER_91_485 VPWR VGND VPWR VGND sky130_ef_sc_hd__decap_12
XFILLER_51_316 VGND VGND VPWR VPWR sky130_fd_sc_hd__fill_1
X_3922_ _3922_/A _3922_/B VGND VGND VPWR VPWR _3923_/B sky130_fd_sc_hd__nand2_1
XTAP_TAPCELL_ROW_102_1358 VGND VPWR sky130_fd_sc_hd__tapvpwrvgnd_1
X_3853_ _3853_/A _3853_/B VGND VGND VPWR VPWR _3854_/B sky130_fd_sc_hd__nor2_1
X_2804_ _4748_/Q _2805_/B VGND VGND VPWR VPWR _2841_/A sky130_fd_sc_hd__nand2_1
X_3784_ _3824_/A _3738_/B _3754_/B VGND VGND VPWR VPWR _3785_/B sky130_fd_sc_hd__a21oi_1
X_2735_ _3440_/A VGND VGND VPWR VPWR _3529_/A sky130_fd_sc_hd__inv_2
X_2666_ _2664_/X _2666_/B VGND VGND VPWR VPWR _2667_/B sky130_fd_sc_hd__nand2b_2
XFILLER_105_329 VGND VGND VPWR VPWR sky130_fd_sc_hd__decap_6
X_4405_ _4734_/CLK _4405_/D fanout146/X VGND VGND VPWR VPWR _4405_/Q sky130_fd_sc_hd__dfrtp_1
XFILLER_99_541 VPWR VGND VPWR VGND sky130_ef_sc_hd__decap_12
XTAP_TAPCELL_ROW_70_1004 VGND VPWR sky130_fd_sc_hd__tapvpwrvgnd_1
X_2597_ _4529_/Q _4524_/Q VGND VGND VPWR VPWR _2598_/B sky130_fd_sc_hd__or2_1
X_4336_ _2325_/C _3599_/S0 _4339_/A2 _4748_/Q VGND VGND VPWR VPWR _4748_/D sky130_fd_sc_hd__a2bb2o_1
XFILLER_99_585 VPWR VGND VPWR VGND sky130_ef_sc_hd__decap_12
XFILLER_59_405 VGND VGND VPWR VPWR sky130_fd_sc_hd__decap_8
X_4267_ _2328_/C input13/X _2328_/B hold133/X VGND VGND VPWR VPWR _4717_/D sky130_fd_sc_hd__a31o_1
X_3218_ _4765_/Q _3219_/B VGND VGND VPWR VPWR _3220_/A sky130_fd_sc_hd__nand2_1
XFILLER_86_268 VGND VGND VPWR VPWR sky130_fd_sc_hd__fill_1
XFILLER_74_419 VGND VGND VPWR VPWR sky130_fd_sc_hd__fill_1
X_4198_ _4697_/Q _4217_/B1 _4213_/A1 _4201_/B VGND VGND VPWR VPWR _4198_/X sky130_fd_sc_hd__a22o_1
X_3149_ _3149_/A VGND VGND VPWR VPWR _3151_/A sky130_fd_sc_hd__inv_2
XFILLER_67_493 VGND VGND VPWR VPWR sky130_fd_sc_hd__decap_8
XFILLER_70_625 VPWR VGND VPWR VGND sky130_ef_sc_hd__decap_12
XTAP_TAPCELL_ROW_25_503 VGND VPWR sky130_fd_sc_hd__tapvpwrvgnd_1
XTAP_TAPCELL_ROW_53_812 VGND VPWR sky130_fd_sc_hd__tapvpwrvgnd_1
XTAP_TAPCELL_ROW_81_1122 VGND VPWR sky130_fd_sc_hd__tapvpwrvgnd_1
XTAP_TAPCELL_ROW_33_591 VGND VPWR sky130_fd_sc_hd__tapvpwrvgnd_1
XTAP_TAPCELL_ROW_92_1240 VGND VPWR sky130_fd_sc_hd__tapvpwrvgnd_1
XFILLER_6_3 VPWR VGND VPWR VGND sky130_ef_sc_hd__decap_12
XFILLER_2_456 VGND VGND VPWR VPWR sky130_fd_sc_hd__decap_8
Xhold280 _4707_/Q VGND VGND VPWR VPWR hold280/X sky130_fd_sc_hd__dlygate4sd3_1
Xhold291 _4516_/Q VGND VGND VPWR VPWR hold291/X sky130_fd_sc_hd__dlygate4sd3_1
XFILLER_1_27 VPWR VGND VPWR VGND sky130_ef_sc_hd__decap_12
XFILLER_105_81 VPWR VGND VPWR VGND sky130_ef_sc_hd__decap_12
XTAP_TAPCELL_ROW_5_283 VGND VPWR sky130_fd_sc_hd__tapvpwrvgnd_1
XFILLER_73_441 VGND VGND VPWR VPWR sky130_fd_sc_hd__decap_6
XFILLER_73_485 VPWR VGND VPWR VGND sky130_ef_sc_hd__decap_12
XFILLER_81_51 VGND VGND VPWR VPWR sky130_fd_sc_hd__decap_4
X_2520_ _2526_/A1 _2517_/X _2521_/B _2526_/B1 _4467_/Q VGND VGND VPWR VPWR _4467_/D
+ sky130_fd_sc_hd__a32o_1
X_2451_ _2451_/A _2451_/B VGND VGND VPWR VPWR _2455_/B sky130_fd_sc_hd__nor2_1
XFILLER_5_272 VGND VGND VPWR VPWR sky130_fd_sc_hd__decap_8
XFILLER_39_3 VPWR VGND VPWR VGND sky130_ef_sc_hd__decap_12
X_2382_ hold288/X _2414_/A2 _2414_/B1 _4547_/Q VGND VGND VPWR VPWR _4397_/D sky130_fd_sc_hd__a22o_1
XFILLER_96_533 VPWR VGND VPWR VGND sky130_ef_sc_hd__decap_12
X_4121_ hold110/X _4030_/X _4121_/S VGND VGND VPWR VPWR _4652_/D sky130_fd_sc_hd__mux2_1
XFILLER_68_224 VPWR VGND VPWR VGND sky130_ef_sc_hd__decap_12
X_4052_ _4133_/A1 hold227/X _4058_/S VGND VGND VPWR VPWR _4590_/D sky130_fd_sc_hd__mux2_1
XFILLER_83_238 VGND VGND VPWR VPWR sky130_fd_sc_hd__decap_6
Xinput4 ui_in[2] VGND VGND VPWR VPWR input4/X sky130_fd_sc_hd__clkbuf_1
XFILLER_49_493 VGND VGND VPWR VPWR sky130_fd_sc_hd__decap_3
X_3003_ _4355_/B2 _3556_/B _3556_/C _3081_/A2 hold289/X VGND VGND VPWR VPWR _4509_/D
+ sky130_fd_sc_hd__a32o_1
XFILLER_36_132 VGND VGND VPWR VPWR sky130_fd_sc_hd__decap_8
XFILLER_101_39 VPWR VGND VPWR VGND sky130_ef_sc_hd__decap_12
XFILLER_91_293 VGND VGND VPWR VPWR sky130_fd_sc_hd__fill_1
XFILLER_51_113 VGND VGND VPWR VPWR sky130_fd_sc_hd__decap_6
X_3905_ _3905_/A _3905_/B VGND VGND VPWR VPWR _3906_/B sky130_fd_sc_hd__xnor2_1
XFILLER_32_360 VGND VGND VPWR VPWR sky130_fd_sc_hd__decap_4
XFILLER_20_522 VGND VGND VPWR VPWR sky130_fd_sc_hd__fill_2
X_3836_ _3836_/A _3836_/B VGND VGND VPWR VPWR _3837_/B sky130_fd_sc_hd__nor2_1
X_3767_ _3767_/A _3767_/B VGND VGND VPWR VPWR _3839_/C sky130_fd_sc_hd__nor2_1
XTAP_TAPCELL_ROW_30_561 VGND VPWR sky130_fd_sc_hd__tapvpwrvgnd_1
X_2718_ _2764_/A _2718_/B VGND VGND VPWR VPWR _2808_/A sky130_fd_sc_hd__nand2_1
X_3698_ _3797_/A _3698_/B VGND VGND VPWR VPWR _3735_/B sky130_fd_sc_hd__nand2_1
XFILLER_105_137 VPWR VGND VPWR VGND sky130_ef_sc_hd__decap_12
X_2649_ _2639_/A _2639_/B _2637_/A VGND VGND VPWR VPWR _2662_/A sky130_fd_sc_hd__o21a_1
XFILLER_86_29 VPWR VGND VPWR VGND sky130_ef_sc_hd__decap_12
XFILLER_99_393 VPWR VGND VPWR VGND sky130_ef_sc_hd__decap_12
X_4319_ hold39/A hold8/A _4427_/Q _4435_/Q _4319_/S0 _2427_/B VGND VGND VPWR VPWR
+ _4320_/A sky130_fd_sc_hd__mux4_1
XTAP_TAPCELL_ROW_2_253 VGND VPWR sky130_fd_sc_hd__tapvpwrvgnd_1
XFILLER_15_316 VGND VGND VPWR VPWR sky130_fd_sc_hd__fill_2
XTAP_TAPCELL_ROW_38_650 VGND VPWR sky130_fd_sc_hd__tapvpwrvgnd_1
XFILLER_35_55 VGND VGND VPWR VPWR sky130_fd_sc_hd__fill_1
XFILLER_70_477 VPWR VGND VPWR VGND sky130_ef_sc_hd__decap_12
XFILLER_70_455 VGND VGND VPWR VPWR sky130_fd_sc_hd__fill_2
XFILLER_30_319 VGND VGND VPWR VPWR sky130_fd_sc_hd__decap_4
XFILLER_42_168 VGND VGND VPWR VPWR sky130_fd_sc_hd__decap_6
XFILLER_42_179 VGND VGND VPWR VPWR sky130_fd_sc_hd__decap_8
XFILLER_11_577 VGND VGND VPWR VPWR sky130_fd_sc_hd__fill_1
XFILLER_7_559 VGND VGND VPWR VPWR sky130_fd_sc_hd__fill_1
XFILLER_51_98 VGND VGND VPWR VPWR sky130_fd_sc_hd__fill_1
XFILLER_78_533 VPWR VGND VPWR VGND sky130_ef_sc_hd__decap_12
XFILLER_93_503 VGND VGND VPWR VPWR sky130_fd_sc_hd__fill_1
XFILLER_38_419 VGND VGND VPWR VPWR sky130_fd_sc_hd__fill_1
XFILLER_76_73 VGND VGND VPWR VPWR sky130_fd_sc_hd__decap_3
XFILLER_65_216 VGND VGND VPWR VPWR sky130_fd_sc_hd__fill_1
XFILLER_19_633 VGND VGND VPWR VPWR sky130_fd_sc_hd__decap_4
XFILLER_33_113 VGND VGND VPWR VPWR sky130_fd_sc_hd__decap_3
XFILLER_92_83 VGND VGND VPWR VPWR sky130_fd_sc_hd__fill_1
X_4670_ _4752_/CLK _4670_/D fanout135/X VGND VGND VPWR VPWR _4670_/Q sky130_fd_sc_hd__dfrtp_1
X_3621_ _3672_/A _3621_/B VGND VGND VPWR VPWR _3626_/A sky130_fd_sc_hd__nand2_1
X_3552_ _3538_/A _3538_/B _3535_/Y VGND VGND VPWR VPWR _3553_/B sky130_fd_sc_hd__o21a_1
X_2503_ _2505_/B _2502_/Y _4462_/Q _2526_/B1 VGND VGND VPWR VPWR _4462_/D sky130_fd_sc_hd__a2bb2o_1
X_3483_ _3556_/A _3483_/B VGND VGND VPWR VPWR _3526_/A sky130_fd_sc_hd__xnor2_1
X_2434_ _4441_/Q _4442_/Q VGND VGND VPWR VPWR _2434_/X sky130_fd_sc_hd__or2_1
X_2365_ hold35/X _2375_/A2 _2375_/B1 _4530_/Q VGND VGND VPWR VPWR _4380_/D sky130_fd_sc_hd__a22o_1
XFILLER_96_363 VGND VGND VPWR VPWR sky130_fd_sc_hd__fill_1
X_4104_ _4113_/A _4140_/B _4113_/C _4140_/D VGND VGND VPWR VPWR _4112_/S sky130_fd_sc_hd__and4b_4
XFILLER_84_525 VGND VGND VPWR VPWR sky130_fd_sc_hd__decap_6
X_2296_ _4691_/Q _2451_/A _4690_/Q _2449_/A _2295_/X VGND VGND VPWR VPWR _2296_/X
+ sky130_fd_sc_hd__o221a_1
XFILLER_56_205 VGND VGND VPWR VPWR sky130_fd_sc_hd__fill_2
XFILLER_84_569 VPWR VGND VPWR VGND sky130_ef_sc_hd__decap_12
X_4035_ _4134_/A1 hold128/X _4040_/S VGND VGND VPWR VPWR _4575_/D sky130_fd_sc_hd__mux2_1
XTAP_TAPCELL_ROW_35_620 VGND VPWR sky130_fd_sc_hd__tapvpwrvgnd_1
XFILLER_52_433 VGND VGND VPWR VPWR sky130_fd_sc_hd__fill_2
XFILLER_52_477 VGND VGND VPWR VPWR sky130_fd_sc_hd__decap_6
XFILLER_12_319 VGND VGND VPWR VPWR sky130_fd_sc_hd__decap_3
X_3819_ _3819_/A _3820_/B VGND VGND VPWR VPWR _3822_/C sky130_fd_sc_hd__nand2_1
XFILLER_106_413 VGND VGND VPWR VPWR sky130_fd_sc_hd__decap_6
XFILLER_21_57 VPWR VGND VPWR VGND sky130_ef_sc_hd__decap_12
XFILLER_106_457 VPWR VGND VPWR VGND sky130_ef_sc_hd__decap_12
XTAP_TAPCELL_ROW_76_1065 VGND VPWR sky130_fd_sc_hd__tapvpwrvgnd_1
XFILLER_97_39 VPWR VGND VPWR VGND sky130_ef_sc_hd__decap_12
XTAP_TAPCELL_ROW_7_312 VGND VPWR sky130_fd_sc_hd__tapvpwrvgnd_1
XPHY_EDGE_ROW_102_Right_102 VGND VGND VPWR VPWR sky130_fd_sc_hd__decap_3
XFILLER_75_503 VGND VGND VPWR VPWR sky130_fd_sc_hd__fill_1
XFILLER_47_249 VGND VGND VPWR VPWR sky130_fd_sc_hd__fill_2
XFILLER_16_614 VGND VGND VPWR VPWR sky130_fd_sc_hd__decap_3
XFILLER_16_625 VGND VGND VPWR VPWR sky130_fd_sc_hd__fill_2
XFILLER_46_65 VGND VGND VPWR VPWR sky130_fd_sc_hd__decap_8
XTAP_TAPCELL_ROW_87_1194 VGND VPWR sky130_fd_sc_hd__tapvpwrvgnd_1
XFILLER_70_285 VGND VGND VPWR VPWR sky130_fd_sc_hd__decap_6
XFILLER_62_53 VPWR VGND VPWR VGND sky130_ef_sc_hd__decap_12
XFILLER_30_138 VGND VGND VPWR VPWR sky130_fd_sc_hd__fill_2
XFILLER_7_301 VGND VGND VPWR VPWR sky130_fd_sc_hd__fill_1
XFILLER_7_15 VPWR VGND VPWR VGND sky130_ef_sc_hd__decap_12
XTAP_TAPCELL_ROW_41_678 VGND VPWR sky130_fd_sc_hd__tapvpwrvgnd_1
XFILLER_97_105 VGND VGND VPWR VPWR sky130_fd_sc_hd__decap_6
XFILLER_3_551 VGND VGND VPWR VPWR sky130_fd_sc_hd__decap_8
XFILLER_97_149 VPWR VGND VPWR VGND sky130_ef_sc_hd__decap_12
XFILLER_78_363 VGND VGND VPWR VPWR sky130_fd_sc_hd__fill_1
XFILLER_66_525 VGND VGND VPWR VPWR sky130_fd_sc_hd__decap_6
XFILLER_38_205 VGND VGND VPWR VPWR sky130_fd_sc_hd__fill_1
XFILLER_66_569 VPWR VGND VPWR VGND sky130_ef_sc_hd__decap_12
XFILLER_38_249 VGND VGND VPWR VPWR sky130_fd_sc_hd__decap_3
XTAP_TAPCELL_ROW_49_767 VGND VPWR sky130_fd_sc_hd__tapvpwrvgnd_1
XFILLER_81_517 VPWR VGND VPWR VGND sky130_ef_sc_hd__decap_12
XFILLER_34_477 VGND VGND VPWR VPWR sky130_fd_sc_hd__decap_8
XFILLER_61_285 VGND VGND VPWR VPWR sky130_fd_sc_hd__decap_4
X_2983_ _4508_/Q _2983_/A2 _3780_/A _2983_/B2 VGND VGND VPWR VPWR _4508_/D sky130_fd_sc_hd__a22o_1
X_4722_ _4735_/CLK _4722_/D fanout148/X VGND VGND VPWR VPWR uo_out[3] sky130_fd_sc_hd__dfrtp_4
X_4653_ _4656_/CLK _4653_/D fanout120/X VGND VGND VPWR VPWR _4653_/Q sky130_fd_sc_hd__dfrtp_1
X_4584_ _4679_/CLK _4584_/D fanout138/X VGND VGND VPWR VPWR _4584_/Q sky130_fd_sc_hd__dfrtp_1
X_3604_ _3628_/C _3604_/B VGND VGND VPWR VPWR _3605_/B sky130_fd_sc_hd__xnor2_1
X_3535_ _3536_/A _3536_/B VGND VGND VPWR VPWR _3535_/Y sky130_fd_sc_hd__nand2_1
XFILLER_107_27 VGND VGND VPWR VPWR sky130_fd_sc_hd__fill_1
XFILLER_103_405 VPWR VGND VPWR VGND sky130_ef_sc_hd__decap_12
XFILLER_89_617 VPWR VGND VPWR VGND sky130_ef_sc_hd__decap_12
X_3466_ _3466_/A _3467_/B VGND VGND VPWR VPWR _3466_/Y sky130_fd_sc_hd__nor2_1
XFILLER_103_449 VPWR VGND VPWR VGND sky130_ef_sc_hd__decap_12
X_2417_ hold270/X _2420_/A2 _2420_/B1 _4518_/Q VGND VGND VPWR VPWR _4432_/D sky130_fd_sc_hd__a22o_1
XFILLER_69_363 VPWR VGND VPWR VGND sky130_ef_sc_hd__decap_12
X_3397_ _3481_/A _3399_/B VGND VGND VPWR VPWR _3397_/X sky130_fd_sc_hd__and2_1
XFILLER_84_322 VGND VGND VPWR VPWR sky130_fd_sc_hd__decap_4
XFILLER_69_396 VGND VGND VPWR VPWR sky130_fd_sc_hd__decap_8
X_2348_ _4361_/Q _2347_/C _4131_/B VGND VGND VPWR VPWR _2349_/B sky130_fd_sc_hd__a21o_1
X_2279_ _4706_/Q _2210_/Y _4705_/Q _2498_/A VGND VGND VPWR VPWR _2279_/X sky130_fd_sc_hd__o22a_1
XFILLER_84_377 VPWR VGND VPWR VGND sky130_ef_sc_hd__decap_12
X_4018_ _4729_/Q _4030_/B VGND VGND VPWR VPWR _4018_/X sky130_fd_sc_hd__and2_2
XFILLER_25_400 VPWR VGND VPWR VGND sky130_ef_sc_hd__decap_12
XFILLER_44_208 VPWR VGND VPWR VGND sky130_ef_sc_hd__decap_12
XFILLER_37_293 VPWR VGND VPWR VGND sky130_ef_sc_hd__decap_12
XTAP_TAPCELL_ROW_10_339 VGND VPWR sky130_fd_sc_hd__tapvpwrvgnd_1
XFILLER_106_221 VPWR VGND VPWR VGND sky130_ef_sc_hd__decap_12
XFILLER_106_3 VPWR VGND VPWR VGND sky130_ef_sc_hd__decap_12
XFILLER_106_265 VPWR VGND VPWR VGND sky130_ef_sc_hd__decap_12
XFILLER_95_609 VGND VGND VPWR VPWR sky130_fd_sc_hd__decap_6
XTAP_TAPCELL_ROW_89_1212 VGND VPWR sky130_fd_sc_hd__tapvpwrvgnd_1
XFILLER_63_517 VPWR VGND VPWR VGND sky130_ef_sc_hd__decap_12
XFILLER_16_411 VGND VGND VPWR VPWR sky130_fd_sc_hd__decap_8
XTAP_TAPCELL_ROW_18_428 VGND VPWR sky130_fd_sc_hd__tapvpwrvgnd_1
XFILLER_28_282 VGND VGND VPWR VPWR sky130_fd_sc_hd__decap_6
XTAP_TAPCELL_ROW_46_737 VGND VPWR sky130_fd_sc_hd__tapvpwrvgnd_1
XFILLER_90_369 VGND VGND VPWR VPWR sky130_fd_sc_hd__fill_1
XFILLER_71_561 VPWR VGND VPWR VGND sky130_ef_sc_hd__decap_12
XFILLER_31_403 VGND VGND VPWR VPWR sky130_fd_sc_hd__decap_4
XFILLER_7_175 VGND VGND VPWR VPWR sky130_fd_sc_hd__decap_3
Xhold109 _4643_/Q VGND VGND VPWR VPWR hold109/X sky130_fd_sc_hd__dlygate4sd3_1
X_3320_ _4624_/Q _4560_/Q _4656_/Q _4592_/Q _3569_/S0 _3283_/S VGND VGND VPWR VPWR
+ _3322_/B sky130_fd_sc_hd__mux4_1
XFILLER_98_469 VGND VGND VPWR VPWR sky130_fd_sc_hd__decap_6
X_3251_ _3232_/B _3234_/B _3230_/X VGND VGND VPWR VPWR _3253_/A sky130_fd_sc_hd__a21o_1
XFILLER_100_419 VGND VGND VPWR VPWR sky130_fd_sc_hd__fill_1
X_3182_ _4545_/Q _4549_/Q VGND VGND VPWR VPWR _3184_/A sky130_fd_sc_hd__nand2_1
XFILLER_21_3 VPWR VGND VPWR VGND sky130_ef_sc_hd__decap_12
X_2202_ _4713_/Q VGND VGND VPWR VPWR _2202_/Y sky130_fd_sc_hd__inv_2
XFILLER_26_219 VGND VGND VPWR VPWR sky130_fd_sc_hd__decap_8
XFILLER_54_517 VGND VGND VPWR VPWR sky130_fd_sc_hd__fill_1
XTAP_TAPCELL_ROW_105_1389 VGND VPWR sky130_fd_sc_hd__tapvpwrvgnd_1
X_2966_ _2911_/B _2963_/X _2965_/Y VGND VGND VPWR VPWR _2967_/B sky130_fd_sc_hd__o21a_1
X_4705_ _4706_/CLK _4705_/D fanout161/X VGND VGND VPWR VPWR _4705_/Q sky130_fd_sc_hd__dfrtp_1
X_2897_ _4505_/Q _2897_/B VGND VGND VPWR VPWR _2898_/B sky130_fd_sc_hd__or2_1
X_4636_ clkload8/A _4636_/D fanout125/X VGND VGND VPWR VPWR hold62/A sky130_fd_sc_hd__dfrtp_1
X_4567_ _4667_/CLK _4567_/D fanout124/X VGND VGND VPWR VPWR hold68/A sky130_fd_sc_hd__dfrtp_1
XTAP_TAPCELL_ROW_73_1035 VGND VPWR sky130_fd_sc_hd__tapvpwrvgnd_1
X_4498_ _4501_/CLK _4498_/D fanout130/X VGND VGND VPWR VPWR _4498_/Q sky130_fd_sc_hd__dfrtp_1
X_3518_ _3479_/A _3516_/B _3515_/X _3517_/Y VGND VGND VPWR VPWR _3575_/A sky130_fd_sc_hd__a31o_1
XFILLER_77_609 VGND VGND VPWR VPWR sky130_fd_sc_hd__decap_6
X_3449_ _3554_/B2 _3447_/X _3466_/A _3470_/B2 _4530_/Q VGND VGND VPWR VPWR _4530_/D
+ sky130_fd_sc_hd__a32o_1
XFILLER_103_279 VGND VGND VPWR VPWR sky130_fd_sc_hd__fill_1
XFILLER_69_160 VGND VGND VPWR VPWR sky130_fd_sc_hd__decap_8
XFILLER_94_29 VPWR VGND VPWR VGND sky130_ef_sc_hd__decap_12
XFILLER_84_141 VGND VGND VPWR VPWR sky130_fd_sc_hd__decap_3
XFILLER_72_347 VGND VGND VPWR VPWR sky130_fd_sc_hd__fill_1
XFILLER_57_388 VGND VGND VPWR VPWR sky130_fd_sc_hd__decap_4
XTAP_TAPCELL_ROW_43_707 VGND VPWR sky130_fd_sc_hd__tapvpwrvgnd_1
XTAP_TAPCELL_ROW_84_1153 VGND VPWR sky130_fd_sc_hd__tapvpwrvgnd_1
XFILLER_25_252 VGND VGND VPWR VPWR sky130_fd_sc_hd__decap_8
XFILLER_25_274 VGND VGND VPWR VPWR sky130_fd_sc_hd__decap_6
XFILLER_53_561 VPWR VGND VPWR VGND sky130_ef_sc_hd__decap_12
XFILLER_43_55 VGND VGND VPWR VPWR sky130_fd_sc_hd__fill_1
XFILLER_40_277 VGND VGND VPWR VPWR sky130_fd_sc_hd__decap_4
XTAP_TAPCELL_ROW_23_486 VGND VPWR sky130_fd_sc_hd__tapvpwrvgnd_1
XFILLER_40_288 VGND VGND VPWR VPWR sky130_fd_sc_hd__fill_2
XTAP_TAPCELL_ROW_51_795 VGND VPWR sky130_fd_sc_hd__tapvpwrvgnd_1
XFILLER_107_585 VGND VGND VPWR VPWR sky130_fd_sc_hd__decap_3
XTAP_TAPCELL_ROW_95_1282 VGND VPWR sky130_fd_sc_hd__tapvpwrvgnd_1
XFILLER_4_27 VGND VGND VPWR VPWR sky130_fd_sc_hd__fill_1
XFILLER_68_41 VPWR VGND VPWR VGND sky130_ef_sc_hd__decap_12
XFILLER_95_417 VPWR VGND VPWR VGND sky130_ef_sc_hd__decap_12
XFILLER_68_85 VGND VGND VPWR VPWR sky130_fd_sc_hd__fill_2
XFILLER_90_122 VPWR VGND VPWR VGND sky130_ef_sc_hd__decap_12
XFILLER_84_73 VGND VGND VPWR VPWR sky130_fd_sc_hd__decap_3
XFILLER_63_325 VGND VGND VPWR VPWR sky130_fd_sc_hd__decap_8
XTAP_TAPCELL_ROW_59_884 VGND VPWR sky130_fd_sc_hd__tapvpwrvgnd_1
XFILLER_16_230 VGND VGND VPWR VPWR sky130_fd_sc_hd__decap_4
XFILLER_44_583 VGND VGND VPWR VPWR sky130_fd_sc_hd__fill_1
X_2820_ _2820_/A _2820_/B _2820_/C VGND VGND VPWR VPWR _2820_/Y sky130_fd_sc_hd__nor3_1
XFILLER_12_491 VGND VGND VPWR VPWR sky130_fd_sc_hd__decap_3
X_2751_ _2751_/A _2820_/B VGND VGND VPWR VPWR _2753_/A sky130_fd_sc_hd__xor2_1
X_2682_ _2662_/A _2657_/Y _2660_/B VGND VGND VPWR VPWR _2683_/B sky130_fd_sc_hd__o21ai_2
XFILLER_69_3 VPWR VGND VPWR VGND sky130_ef_sc_hd__decap_12
X_4421_ _4504_/CLK _4421_/D fanout154/X VGND VGND VPWR VPWR _4421_/Q sky130_fd_sc_hd__dfrtp_1
X_4352_ _3468_/A _3917_/A _4354_/A2 _4764_/Q VGND VGND VPWR VPWR _4764_/D sky130_fd_sc_hd__a2bb2o_1
XFILLER_98_233 VPWR VGND VPWR VGND sky130_ef_sc_hd__decap_12
XFILLER_59_609 VGND VGND VPWR VPWR sky130_fd_sc_hd__decap_6
X_3303_ _3303_/A _3303_/B VGND VGND VPWR VPWR _3306_/A sky130_fd_sc_hd__xnor2_1
X_4283_ _4283_/A _4283_/B VGND VGND VPWR VPWR _4283_/Y sky130_fd_sc_hd__nor2_1
XFILLER_98_277 VPWR VGND VPWR VGND sky130_ef_sc_hd__decap_12
X_3234_ _3234_/A _3234_/B VGND VGND VPWR VPWR _3240_/A sky130_fd_sc_hd__xnor2_1
XTAP_TAPCELL_ROW_107_1407 VGND VPWR sky130_fd_sc_hd__tapvpwrvgnd_1
XFILLER_82_601 VPWR VGND VPWR VGND sky130_ef_sc_hd__decap_12
X_3165_ _3165_/A _3165_/B VGND VGND VPWR VPWR _3166_/B sky130_fd_sc_hd__xnor2_1
XFILLER_66_152 VGND VGND VPWR VPWR sky130_fd_sc_hd__fill_2
XFILLER_39_377 VPWR VGND VPWR VGND sky130_ef_sc_hd__decap_12
XTAP_TAPCELL_ROW_107_1418 VGND VPWR sky130_fd_sc_hd__tapvpwrvgnd_1
X_3096_ _3096_/A _3096_/B VGND VGND VPWR VPWR _3098_/B sky130_fd_sc_hd__xnor2_2
XFILLER_66_174 VGND VGND VPWR VPWR sky130_fd_sc_hd__fill_2
XFILLER_27_528 VGND VGND VPWR VPWR sky130_fd_sc_hd__decap_4
XFILLER_54_325 VGND VGND VPWR VPWR sky130_fd_sc_hd__decap_4
XFILLER_35_561 VGND VGND VPWR VPWR sky130_fd_sc_hd__decap_8
XFILLER_22_233 VGND VGND VPWR VPWR sky130_fd_sc_hd__fill_2
Xfanout15 _3267_/Y VGND VGND VPWR VPWR _3599_/S0 sky130_fd_sc_hd__clkbuf_4
XFILLER_35_594 VPWR VGND VPWR VGND sky130_ef_sc_hd__decap_12
Xfanout26 _2535_/A2 VGND VGND VPWR VPWR _2526_/B1 sky130_fd_sc_hd__buf_2
Xfanout37 _4265_/B VGND VGND VPWR VPWR _2407_/B1 sky130_fd_sc_hd__buf_2
Xfanout59 _4206_/B1 VGND VGND VPWR VPWR _4217_/B1 sky130_fd_sc_hd__buf_2
Xfanout48 _4030_/X VGND VGND VPWR VPWR _4139_/A1 sky130_fd_sc_hd__clkbuf_4
X_3998_ _4030_/B VGND VGND VPWR VPWR _4012_/A sky130_fd_sc_hd__inv_2
XFILLER_50_553 VPWR VGND VPWR VGND sky130_ef_sc_hd__decap_12
XFILLER_50_586 VGND VGND VPWR VPWR sky130_fd_sc_hd__fill_2
X_2949_ _3014_/A _2949_/B VGND VGND VPWR VPWR _2950_/B sky130_fd_sc_hd__xor2_1
XFILLER_13_69 VPWR VGND VPWR VGND sky130_ef_sc_hd__decap_12
XTAP_TAPCELL_ROW_20_456 VGND VPWR sky130_fd_sc_hd__tapvpwrvgnd_1
X_4619_ _4684_/CLK _4619_/D fanout141/X VGND VGND VPWR VPWR hold54/A sky130_fd_sc_hd__dfrtp_1
XFILLER_89_222 VGND VGND VPWR VPWR sky130_fd_sc_hd__fill_2
XFILLER_89_211 VGND VGND VPWR VPWR sky130_fd_sc_hd__fill_1
XFILLER_104_533 VPWR VGND VPWR VGND sky130_ef_sc_hd__decap_12
Xstream_cipher_183 VGND VGND VPWR VPWR stream_cipher_183/HI uio_out[5] sky130_fd_sc_hd__conb_1
XFILLER_89_266 VPWR VGND VPWR VGND sky130_ef_sc_hd__decap_12
XFILLER_77_417 VGND VGND VPWR VPWR sky130_fd_sc_hd__fill_1
XFILLER_85_461 VPWR VGND VPWR VGND sky130_ef_sc_hd__decap_12
XFILLER_38_77 VGND VGND VPWR VPWR sky130_fd_sc_hd__decap_6
XTAP_TAPCELL_ROW_28_545 VGND VPWR sky130_fd_sc_hd__tapvpwrvgnd_1
XTAP_TAPCELL_ROW_56_843 VGND VPWR sky130_fd_sc_hd__tapvpwrvgnd_1
XFILLER_26_583 VGND VGND VPWR VPWR sky130_fd_sc_hd__fill_2
XFILLER_70_53 VPWR VGND VPWR VGND sky130_ef_sc_hd__decap_12
XTAP_TAPCELL_ROW_97_1300 VGND VPWR sky130_fd_sc_hd__tapvpwrvgnd_1
Xclkload29 _4519_/CLK VGND VGND VPWR VPWR clkload29/Y sky130_fd_sc_hd__inv_6
XFILLER_70_97 VGND VGND VPWR VPWR sky130_fd_sc_hd__decap_6
Xclkload18 _4752_/CLK VGND VGND VPWR VPWR clkload18/X sky130_fd_sc_hd__clkbuf_4
XFILLER_79_51 VGND VGND VPWR VPWR sky130_fd_sc_hd__decap_4
XFILLER_5_498 VGND VGND VPWR VPWR sky130_fd_sc_hd__decap_6
XFILLER_107_393 VPWR VGND VPWR VGND sky130_ef_sc_hd__decap_12
XFILLER_95_225 VPWR VGND VPWR VGND sky130_ef_sc_hd__decap_12
XFILLER_64_601 VPWR VGND VPWR VGND sky130_ef_sc_hd__decap_12
XFILLER_48_141 VGND VGND VPWR VPWR sky130_fd_sc_hd__fill_1
XFILLER_63_122 VGND VGND VPWR VPWR sky130_fd_sc_hd__decap_4
XFILLER_91_497 VGND VGND VPWR VPWR sky130_fd_sc_hd__decap_6
XFILLER_63_177 VGND VGND VPWR VPWR sky130_fd_sc_hd__decap_3
XFILLER_17_561 VGND VGND VPWR VPWR sky130_fd_sc_hd__decap_8
XFILLER_51_328 VGND VGND VPWR VPWR sky130_fd_sc_hd__fill_1
X_3921_ _3922_/A _3922_/B VGND VGND VPWR VPWR _3921_/Y sky130_fd_sc_hd__nor2_1
XFILLER_32_520 VGND VGND VPWR VPWR sky130_fd_sc_hd__fill_1
XTAP_TAPCELL_ROW_102_1359 VGND VPWR sky130_fd_sc_hd__tapvpwrvgnd_1
X_3852_ _3853_/A _3853_/B VGND VGND VPWR VPWR _3878_/A sky130_fd_sc_hd__and2_1
XFILLER_32_553 VPWR VGND VPWR VGND sky130_ef_sc_hd__decap_12
X_2803_ _4569_/Q _4601_/Q hold72/A _4665_/Q _2746_/S _2837_/S1 VGND VGND VPWR VPWR
+ _2805_/B sky130_fd_sc_hd__mux4_1
X_3783_ _3783_/A _3783_/B VGND VGND VPWR VPWR _3787_/A sky130_fd_sc_hd__nand2_1
X_2734_ _2734_/A _2757_/A VGND VGND VPWR VPWR _3440_/A sky130_fd_sc_hd__xnor2_4
X_2665_ _4495_/Q _2665_/B VGND VGND VPWR VPWR _2666_/B sky130_fd_sc_hd__or2_1
X_2596_ _4529_/Q _4524_/Q VGND VGND VPWR VPWR _2598_/A sky130_fd_sc_hd__nand2_1
X_4404_ _4734_/CLK _4404_/D fanout146/X VGND VGND VPWR VPWR _4404_/Q sky130_fd_sc_hd__dfrtp_1
XFILLER_99_553 VGND VGND VPWR VPWR sky130_fd_sc_hd__decap_6
X_4335_ _4747_/Q _4339_/A2 _3519_/S _4339_/B2 VGND VGND VPWR VPWR _4747_/D sky130_fd_sc_hd__a22o_1
XFILLER_101_503 VGND VGND VPWR VPWR sky130_fd_sc_hd__fill_1
XFILLER_99_597 VPWR VGND VPWR VGND sky130_ef_sc_hd__decap_12
XTAP_TAPCELL_ROW_70_1005 VGND VPWR sky130_fd_sc_hd__tapvpwrvgnd_1
X_4266_ hold198/X _4264_/A _4265_/X _4715_/Q VGND VGND VPWR VPWR _4716_/D sky130_fd_sc_hd__a22o_1
X_3217_ _4586_/Q hold41/A _4650_/Q hold65/A _3246_/S0 _3246_/S1 VGND VGND VPWR VPWR
+ _3219_/B sky130_fd_sc_hd__mux4_1
X_4197_ _4697_/Q _4197_/B VGND VGND VPWR VPWR _4201_/B sky130_fd_sc_hd__nand2_1
X_3148_ _4515_/Q _3148_/B VGND VGND VPWR VPWR _3149_/A sky130_fd_sc_hd__xnor2_1
XFILLER_39_185 VPWR VGND VPWR VGND sky130_ef_sc_hd__decap_12
XFILLER_82_475 VGND VGND VPWR VPWR sky130_fd_sc_hd__fill_1
X_3079_ _3105_/A _3079_/B VGND VGND VPWR VPWR _3880_/A sky130_fd_sc_hd__xnor2_4
XTAP_TAPCELL_ROW_25_504 VGND VPWR sky130_fd_sc_hd__tapvpwrvgnd_1
XTAP_TAPCELL_ROW_53_813 VGND VPWR sky130_fd_sc_hd__tapvpwrvgnd_1
XTAP_TAPCELL_ROW_81_1123 VGND VPWR sky130_fd_sc_hd__tapvpwrvgnd_1
XFILLER_50_361 VGND VGND VPWR VPWR sky130_fd_sc_hd__decap_3
XFILLER_10_225 VGND VGND VPWR VPWR sky130_fd_sc_hd__fill_2
XTAP_TAPCELL_ROW_33_592 VGND VPWR sky130_fd_sc_hd__tapvpwrvgnd_1
XFILLER_6_218 VPWR VGND VPWR VGND sky130_ef_sc_hd__decap_12
XTAP_TAPCELL_ROW_79_1096 VGND VPWR sky130_fd_sc_hd__tapvpwrvgnd_1
XTAP_TAPCELL_ROW_92_1241 VGND VPWR sky130_fd_sc_hd__tapvpwrvgnd_1
Xhold270 _4432_/Q VGND VGND VPWR VPWR hold270/X sky130_fd_sc_hd__dlygate4sd3_1
XFILLER_2_446 VGND VGND VPWR VPWR sky130_fd_sc_hd__fill_1
XFILLER_104_363 VGND VGND VPWR VPWR sky130_fd_sc_hd__fill_1
Xhold292 _4622_/Q VGND VGND VPWR VPWR hold292/X sky130_fd_sc_hd__dlygate4sd3_1
Xhold281 _4466_/Q VGND VGND VPWR VPWR hold281/X sky130_fd_sc_hd__dlygate4sd3_1
XFILLER_77_247 VPWR VGND VPWR VGND sky130_ef_sc_hd__decap_12
XFILLER_49_65 VGND VGND VPWR VPWR sky130_fd_sc_hd__fill_2
XFILLER_49_87 VGND VGND VPWR VPWR sky130_fd_sc_hd__fill_1
XFILLER_105_93 VPWR VGND VPWR VGND sky130_ef_sc_hd__decap_12
XTAP_TAPCELL_ROW_69_990 VGND VPWR sky130_fd_sc_hd__tapvpwrvgnd_1
XTAP_TAPCELL_ROW_5_284 VGND VPWR sky130_fd_sc_hd__tapvpwrvgnd_1
XFILLER_1_39 VPWR VGND VPWR VGND sky130_ef_sc_hd__decap_12
XFILLER_61_615 VGND VGND VPWR VPWR sky130_fd_sc_hd__fill_1
XFILLER_73_497 VGND VGND VPWR VPWR sky130_fd_sc_hd__decap_6
XFILLER_60_136 VGND VGND VPWR VPWR sky130_fd_sc_hd__decap_4
XFILLER_60_158 VGND VGND VPWR VPWR sky130_fd_sc_hd__decap_4
X_2450_ _2486_/A1 _2451_/B _2449_/Y _2486_/B1 hold66/X VGND VGND VPWR VPWR _4446_/D
+ sky130_fd_sc_hd__a32o_1
XFILLER_96_501 VPWR VGND VPWR VGND sky130_ef_sc_hd__decap_12
X_2381_ hold63/X _2408_/A2 _2408_/B1 _3836_/A VGND VGND VPWR VPWR _4396_/D sky130_fd_sc_hd__a22o_1
XFILLER_96_545 VPWR VGND VPWR VGND sky130_ef_sc_hd__decap_12
X_4120_ hold137/X _4028_/X _4121_/S VGND VGND VPWR VPWR _4651_/D sky130_fd_sc_hd__mux2_1
XFILLER_68_236 VPWR VGND VPWR VGND sky130_ef_sc_hd__decap_12
XFILLER_96_589 VPWR VGND VPWR VGND sky130_ef_sc_hd__decap_12
X_4051_ _4132_/A1 hold242/X _4058_/S VGND VGND VPWR VPWR _4589_/D sky130_fd_sc_hd__mux2_1
Xinput5 ui_in[3] VGND VGND VPWR VPWR input5/X sky130_fd_sc_hd__clkbuf_1
X_3002_ _3556_/B _3556_/C VGND VGND VPWR VPWR _3797_/A sky130_fd_sc_hd__nand2_1
XFILLER_64_475 VGND VGND VPWR VPWR sky130_fd_sc_hd__fill_1
XFILLER_24_306 VGND VGND VPWR VPWR sky130_fd_sc_hd__fill_2
XFILLER_24_317 VGND VGND VPWR VPWR sky130_fd_sc_hd__decap_6
X_3904_ _3884_/A _3884_/B _3881_/Y VGND VGND VPWR VPWR _3905_/B sky130_fd_sc_hd__a21oi_1
XFILLER_32_372 VPWR VGND VPWR VGND sky130_ef_sc_hd__decap_12
X_3835_ _3836_/A _3836_/B VGND VGND VPWR VPWR _3847_/A sky130_fd_sc_hd__and2_1
XFILLER_20_556 VGND VGND VPWR VPWR sky130_fd_sc_hd__decap_6
X_3766_ _3767_/B VGND VGND VPWR VPWR _3766_/Y sky130_fd_sc_hd__inv_2
XFILLER_20_589 VGND VGND VPWR VPWR sky130_fd_sc_hd__decap_8
XTAP_TAPCELL_ROW_30_562 VGND VPWR sky130_fd_sc_hd__tapvpwrvgnd_1
X_2717_ _4744_/Q _2717_/B VGND VGND VPWR VPWR _2718_/B sky130_fd_sc_hd__or2_1
XFILLER_105_105 VGND VGND VPWR VPWR sky130_fd_sc_hd__decap_6
XFILLER_10_15 VPWR VGND VPWR VGND sky130_ef_sc_hd__decap_12
X_3697_ _3797_/A _3698_/B VGND VGND VPWR VPWR _3699_/A sky130_fd_sc_hd__or2_1
XFILLER_105_149 VPWR VGND VPWR VGND sky130_ef_sc_hd__decap_12
X_2648_ _2673_/A _2648_/B VGND VGND VPWR VPWR _2663_/A sky130_fd_sc_hd__nor2_1
XFILLER_99_361 VPWR VGND VPWR VGND sky130_ef_sc_hd__decap_12
X_2579_ _4622_/Q _4654_/Q _3278_/A VGND VGND VPWR VPWR _2579_/X sky130_fd_sc_hd__mux2_1
X_4318_ _4318_/A _4318_/B VGND VGND VPWR VPWR _4318_/Y sky130_fd_sc_hd__nor2_1
XFILLER_59_225 VGND VGND VPWR VPWR sky130_fd_sc_hd__fill_2
X_4249_ _4265_/B _4250_/B _4248_/X _4262_/A _4711_/Q VGND VGND VPWR VPWR _4711_/D
+ sky130_fd_sc_hd__a32o_1
XFILLER_19_57 VPWR VGND VPWR VGND sky130_ef_sc_hd__decap_12
XFILLER_28_612 VGND VGND VPWR VPWR sky130_fd_sc_hd__decap_3
XTAP_TAPCELL_ROW_2_254 VGND VPWR sky130_fd_sc_hd__tapvpwrvgnd_1
XFILLER_82_250 VGND VGND VPWR VPWR sky130_fd_sc_hd__fill_2
XTAP_TAPCELL_ROW_66_960 VGND VPWR sky130_fd_sc_hd__tapvpwrvgnd_1
XTAP_TAPCELL_ROW_38_651 VGND VPWR sky130_fd_sc_hd__tapvpwrvgnd_1
XFILLER_43_604 VGND VGND VPWR VPWR sky130_fd_sc_hd__fill_1
XFILLER_82_294 VGND VGND VPWR VPWR sky130_fd_sc_hd__decap_4
XFILLER_42_136 VGND VGND VPWR VPWR sky130_fd_sc_hd__decap_4
XFILLER_30_309 VGND VGND VPWR VPWR sky130_fd_sc_hd__decap_6
XFILLER_42_147 VGND VGND VPWR VPWR sky130_fd_sc_hd__fill_1
XFILLER_70_489 VPWR VGND VPWR VGND sky130_ef_sc_hd__decap_12
XFILLER_7_527 VGND VGND VPWR VPWR sky130_fd_sc_hd__decap_3
XFILLER_51_55 VGND VGND VPWR VPWR sky130_fd_sc_hd__fill_1
XFILLER_78_501 VPWR VGND VPWR VGND sky130_ef_sc_hd__decap_12
XFILLER_78_545 VPWR VGND VPWR VGND sky130_ef_sc_hd__decap_12
XFILLER_76_41 VPWR VGND VPWR VGND sky130_ef_sc_hd__decap_12
XFILLER_78_589 VPWR VGND VPWR VGND sky130_ef_sc_hd__decap_12
XFILLER_76_85 VGND VGND VPWR VPWR sky130_fd_sc_hd__decap_6
XFILLER_93_559 VGND VGND VPWR VPWR sky130_fd_sc_hd__fill_1
XFILLER_80_209 VGND VGND VPWR VPWR sky130_fd_sc_hd__decap_3
XFILLER_61_434 VGND VGND VPWR VPWR sky130_fd_sc_hd__fill_2
XFILLER_18_188 VGND VGND VPWR VPWR sky130_fd_sc_hd__fill_1
XFILLER_33_136 VGND VGND VPWR VPWR sky130_fd_sc_hd__decap_6
XFILLER_33_158 VGND VGND VPWR VPWR sky130_fd_sc_hd__fill_2
X_3620_ _3620_/A _3620_/B VGND VGND VPWR VPWR _3621_/B sky130_fd_sc_hd__or2_1
X_3551_ _4535_/Q _3551_/B VGND VGND VPWR VPWR _3585_/B sky130_fd_sc_hd__xor2_1
XFILLER_6_571 VPWR VGND VPWR VGND sky130_ef_sc_hd__decap_12
X_2502_ _4462_/Q _2498_/Y _2526_/A1 VGND VGND VPWR VPWR _2502_/Y sky130_fd_sc_hd__o21ai_1
X_3482_ _3556_/A _3483_/B VGND VGND VPWR VPWR _3482_/X sky130_fd_sc_hd__xor2_1
XFILLER_51_3 VPWR VGND VPWR VGND sky130_ef_sc_hd__decap_12
XFILLER_103_609 VGND VGND VPWR VPWR sky130_fd_sc_hd__decap_6
XFILLER_69_501 VGND VGND VPWR VPWR sky130_fd_sc_hd__decap_3
X_2433_ _2486_/A1 _2486_/B1 _4441_/Q VGND VGND VPWR VPWR _4441_/D sky130_fd_sc_hd__mux2_1
X_2364_ hold167/X _2375_/A2 _2375_/B1 _4529_/Q VGND VGND VPWR VPWR _4379_/D sky130_fd_sc_hd__a22o_1
XPHY_EDGE_ROW_16_Left_124 VGND VGND VPWR VPWR sky130_fd_sc_hd__decap_3
XFILLER_29_409 VGND VGND VPWR VPWR sky130_fd_sc_hd__fill_1
X_4103_ _4013_/B _4094_/B _4139_/A1 _4094_/Y hold62/X VGND VGND VPWR VPWR _4636_/D
+ sky130_fd_sc_hd__a32o_1
X_2295_ _4690_/Q _2449_/A _4689_/Q _2188_/Y _2294_/X VGND VGND VPWR VPWR _2295_/X
+ sky130_fd_sc_hd__a221o_1
X_4034_ _4133_/A1 hold162/X _4040_/S VGND VGND VPWR VPWR _4574_/D sky130_fd_sc_hd__mux2_1
XFILLER_64_261 VGND VGND VPWR VPWR sky130_fd_sc_hd__fill_2
XFILLER_37_475 VGND VGND VPWR VPWR sky130_fd_sc_hd__decap_3
XFILLER_52_401 VGND VGND VPWR VPWR sky130_fd_sc_hd__fill_2
XFILLER_92_581 VGND VGND VPWR VPWR sky130_fd_sc_hd__decap_6
XTAP_TAPCELL_ROW_63_930 VGND VPWR sky130_fd_sc_hd__tapvpwrvgnd_1
XTAP_TAPCELL_ROW_35_621 VGND VPWR sky130_fd_sc_hd__tapvpwrvgnd_1
XPHY_EDGE_ROW_25_Left_133 VGND VGND VPWR VPWR sky130_fd_sc_hd__decap_3
XFILLER_32_191 VGND VGND VPWR VPWR sky130_fd_sc_hd__decap_4
X_3818_ _3856_/A _3818_/B VGND VGND VPWR VPWR _3822_/B sky130_fd_sc_hd__nand2_1
X_3749_ _3824_/A _3738_/B _3741_/A VGND VGND VPWR VPWR _3763_/A sky130_fd_sc_hd__a21bo_1
XFILLER_21_69 VPWR VGND VPWR VGND sky130_ef_sc_hd__decap_12
XTAP_TAPCELL_ROW_76_1066 VGND VPWR sky130_fd_sc_hd__tapvpwrvgnd_1
XFILLER_106_469 VGND VGND VPWR VPWR sky130_fd_sc_hd__decap_6
XTAP_TAPCELL_ROW_7_313 VGND VPWR sky130_fd_sc_hd__tapvpwrvgnd_1
XPHY_EDGE_ROW_34_Left_142 VGND VGND VPWR VPWR sky130_fd_sc_hd__decap_3
XFILLER_87_397 VGND VGND VPWR VPWR sky130_fd_sc_hd__fill_1
XFILLER_87_375 VGND VGND VPWR VPWR sky130_fd_sc_hd__decap_4
XFILLER_75_559 VGND VGND VPWR VPWR sky130_fd_sc_hd__fill_1
XFILLER_62_209 VGND VGND VPWR VPWR sky130_fd_sc_hd__decap_4
XFILLER_28_464 VPWR VGND VPWR VGND sky130_ef_sc_hd__decap_12
XTAP_TAPCELL_ROW_87_1184 VGND VPWR sky130_fd_sc_hd__tapvpwrvgnd_1
XFILLER_70_253 VGND VGND VPWR VPWR sky130_fd_sc_hd__decap_3
XFILLER_70_242 VGND VGND VPWR VPWR sky130_fd_sc_hd__decap_8
XFILLER_70_231 VGND VGND VPWR VPWR sky130_fd_sc_hd__decap_3
XFILLER_15_147 VGND VGND VPWR VPWR sky130_fd_sc_hd__fill_1
XFILLER_43_456 VPWR VGND VPWR VGND sky130_ef_sc_hd__decap_12
XFILLER_102_83 VGND VGND VPWR VPWR sky130_fd_sc_hd__fill_1
XPHY_EDGE_ROW_43_Left_151 VGND VGND VPWR VPWR sky130_fd_sc_hd__decap_3
XFILLER_62_65 VPWR VGND VPWR VGND sky130_ef_sc_hd__decap_12
XFILLER_7_324 VGND VGND VPWR VPWR sky130_fd_sc_hd__fill_1
XFILLER_7_27 VPWR VGND VPWR VGND sky130_ef_sc_hd__decap_12
XTAP_TAPCELL_ROW_41_679 VGND VPWR sky130_fd_sc_hd__tapvpwrvgnd_1
XPHY_EDGE_ROW_52_Left_160 VGND VGND VPWR VPWR sky130_fd_sc_hd__decap_3
XFILLER_87_51 VGND VGND VPWR VPWR sky130_fd_sc_hd__decap_4
XFILLER_93_334 VGND VGND VPWR VPWR sky130_fd_sc_hd__fill_2
XFILLER_19_442 VGND VGND VPWR VPWR sky130_fd_sc_hd__decap_6
XFILLER_81_529 VPWR VGND VPWR VGND sky130_ef_sc_hd__decap_12
XTAP_TAPCELL_ROW_49_768 VGND VPWR sky130_fd_sc_hd__tapvpwrvgnd_1
XFILLER_74_581 VGND VGND VPWR VPWR sky130_fd_sc_hd__decap_6
XFILLER_46_283 VPWR VGND VPWR VGND sky130_ef_sc_hd__decap_12
XFILLER_99_3 VPWR VGND VPWR VGND sky130_ef_sc_hd__decap_12
X_2982_ _3000_/B _2982_/B VGND VGND VPWR VPWR _3780_/A sky130_fd_sc_hd__and2_2
XFILLER_14_191 VGND VGND VPWR VPWR sky130_fd_sc_hd__decap_4
X_4721_ _4721_/CLK _4721_/D fanout149/X VGND VGND VPWR VPWR uo_out[2] sky130_fd_sc_hd__dfrtp_4
X_4652_ _4764_/CLK _4652_/D fanout141/X VGND VGND VPWR VPWR _4652_/Q sky130_fd_sc_hd__dfrtp_1
X_3603_ _3603_/A _3603_/B VGND VGND VPWR VPWR _3604_/B sky130_fd_sc_hd__nand2_1
X_4583_ _4764_/CLK _4583_/D fanout140/X VGND VGND VPWR VPWR _4583_/Q sky130_fd_sc_hd__dfrtp_1
X_3534_ _3534_/A _3534_/B VGND VGND VPWR VPWR _3536_/B sky130_fd_sc_hd__xnor2_2
XFILLER_89_629 VGND VGND VPWR VPWR sky130_fd_sc_hd__decap_8
X_3465_ _4531_/Q _3465_/B VGND VGND VPWR VPWR _3467_/B sky130_fd_sc_hd__xnor2_1
XFILLER_103_417 VPWR VGND VPWR VGND sky130_ef_sc_hd__decap_12
XFILLER_88_139 VGND VGND VPWR VPWR sky130_fd_sc_hd__fill_1
X_2416_ hold269/X _2420_/A2 _2420_/B1 _4517_/Q VGND VGND VPWR VPWR _4431_/D sky130_fd_sc_hd__a22o_1
XFILLER_69_353 VGND VGND VPWR VPWR sky130_fd_sc_hd__fill_2
X_3396_ _3396_/A _3592_/A VGND VGND VPWR VPWR _3399_/B sky130_fd_sc_hd__xnor2_1
X_2347_ _4140_/B _4131_/B _2347_/C VGND VGND VPWR VPWR _2347_/X sky130_fd_sc_hd__and3_1
XFILLER_29_239 VPWR VGND VPWR VGND sky130_ef_sc_hd__decap_12
X_2278_ _4707_/Q _2209_/Y _4706_/Q _2210_/Y _2276_/X VGND VGND VPWR VPWR _2278_/X
+ sky130_fd_sc_hd__a221o_1
XFILLER_57_559 VGND VGND VPWR VPWR sky130_fd_sc_hd__fill_1
XFILLER_84_389 VGND VGND VPWR VPWR sky130_fd_sc_hd__decap_8
X_4017_ _4132_/A1 _4095_/B _4016_/B _4016_/Y hold115/X VGND VGND VPWR VPWR _4565_/D
+ sky130_fd_sc_hd__a32o_1
XFILLER_25_412 VGND VGND VPWR VPWR sky130_fd_sc_hd__decap_4
XFILLER_13_607 VGND VGND VPWR VPWR sky130_fd_sc_hd__decap_8
XFILLER_52_253 VGND VGND VPWR VPWR sky130_fd_sc_hd__decap_4
XFILLER_4_316 VGND VGND VPWR VPWR sky130_fd_sc_hd__fill_2
XFILLER_106_233 VPWR VGND VPWR VGND sky130_ef_sc_hd__decap_12
XFILLER_79_106 VGND VGND VPWR VPWR sky130_fd_sc_hd__decap_6
XFILLER_106_277 VPWR VGND VPWR VGND sky130_ef_sc_hd__decap_12
XFILLER_0_533 VPWR VGND VPWR VGND sky130_ef_sc_hd__decap_12
XFILLER_94_109 VPWR VGND VPWR VGND sky130_ef_sc_hd__decap_12
XTAP_TAPCELL_ROW_89_1213 VGND VPWR sky130_fd_sc_hd__tapvpwrvgnd_1
XFILLER_48_504 VGND VGND VPWR VPWR sky130_fd_sc_hd__fill_1
XFILLER_63_529 VPWR VGND VPWR VGND sky130_ef_sc_hd__decap_12
XTAP_TAPCELL_ROW_18_429 VGND VPWR sky130_fd_sc_hd__tapvpwrvgnd_1
XFILLER_28_261 VGND VGND VPWR VPWR sky130_fd_sc_hd__fill_1
XTAP_TAPCELL_ROW_46_738 VGND VPWR sky130_fd_sc_hd__tapvpwrvgnd_1
XFILLER_56_581 VGND VGND VPWR VPWR sky130_fd_sc_hd__decap_6
XFILLER_71_573 VPWR VGND VPWR VGND sky130_ef_sc_hd__decap_12
XFILLER_8_600 VGND VGND VPWR VPWR sky130_fd_sc_hd__fill_1
XFILLER_7_165 VGND VGND VPWR VPWR sky130_fd_sc_hd__decap_3
XFILLER_98_83 VGND VGND VPWR VPWR sky130_fd_sc_hd__fill_1
X_3250_ _3250_/A _3250_/B VGND VGND VPWR VPWR _3254_/A sky130_fd_sc_hd__xnor2_1
XFILLER_3_393 VPWR VGND VPWR VGND sky130_ef_sc_hd__decap_12
XFILLER_85_109 VGND VGND VPWR VPWR sky130_fd_sc_hd__decap_3
XFILLER_78_150 VGND VGND VPWR VPWR sky130_fd_sc_hd__fill_2
X_3181_ hold28/A _3162_/B _3164_/X VGND VGND VPWR VPWR _3185_/A sky130_fd_sc_hd__a21oi_1
X_2201_ hold61/A VGND VGND VPWR VPWR _2529_/A sky130_fd_sc_hd__inv_2
XFILLER_14_3 VPWR VGND VPWR VGND sky130_ef_sc_hd__decap_12
XFILLER_81_304 VPWR VGND VPWR VGND sky130_ef_sc_hd__decap_12
XFILLER_81_337 VPWR VGND VPWR VGND sky130_ef_sc_hd__decap_12
XFILLER_34_253 VGND VGND VPWR VPWR sky130_fd_sc_hd__decap_6
X_4704_ _4706_/CLK _4704_/D fanout161/X VGND VGND VPWR VPWR _4704_/Q sky130_fd_sc_hd__dfrtp_1
X_2965_ _2965_/A VGND VGND VPWR VPWR _2965_/Y sky130_fd_sc_hd__inv_2
X_2896_ _4505_/Q _2897_/B VGND VGND VPWR VPWR _2896_/Y sky130_fd_sc_hd__nor2_1
X_4635_ clkload8/A _4635_/D fanout125/X VGND VGND VPWR VPWR hold67/A sky130_fd_sc_hd__dfrtp_1
X_4566_ clkload7/A _4566_/D fanout127/X VGND VGND VPWR VPWR hold92/A sky130_fd_sc_hd__dfrtp_1
X_3517_ _3517_/A _3517_/B VGND VGND VPWR VPWR _3517_/Y sky130_fd_sc_hd__nand2_1
XFILLER_103_225 VPWR VGND VPWR VGND sky130_ef_sc_hd__decap_12
XTAP_TAPCELL_ROW_73_1036 VGND VPWR sky130_fd_sc_hd__tapvpwrvgnd_1
X_4497_ _4499_/CLK _4497_/D fanout132/X VGND VGND VPWR VPWR _4497_/Q sky130_fd_sc_hd__dfrtp_1
X_3448_ _3448_/A _3448_/B VGND VGND VPWR VPWR _3466_/A sky130_fd_sc_hd__nand2_1
X_3379_ _3378_/A _3378_/B _3378_/C VGND VGND VPWR VPWR _3380_/C sky130_fd_sc_hd__o21ai_1
XFILLER_17_209 VGND VGND VPWR VPWR sky130_fd_sc_hd__fill_1
XFILLER_84_197 VGND VGND VPWR VPWR sky130_fd_sc_hd__decap_3
XFILLER_27_57 VPWR VGND VPWR VGND sky130_ef_sc_hd__decap_12
XTAP_TAPCELL_ROW_43_708 VGND VPWR sky130_fd_sc_hd__tapvpwrvgnd_1
XTAP_TAPCELL_ROW_84_1154 VGND VPWR sky130_fd_sc_hd__tapvpwrvgnd_1
XFILLER_80_370 VGND VGND VPWR VPWR sky130_fd_sc_hd__fill_1
XFILLER_53_573 VPWR VGND VPWR VGND sky130_ef_sc_hd__decap_12
XTAP_TAPCELL_ROW_23_487 VGND VPWR sky130_fd_sc_hd__tapvpwrvgnd_1
XTAP_TAPCELL_ROW_51_796 VGND VPWR sky130_fd_sc_hd__tapvpwrvgnd_1
XTAP_TAPCELL_ROW_95_1272 VGND VPWR sky130_fd_sc_hd__tapvpwrvgnd_1
XFILLER_68_53 VPWR VGND VPWR VGND sky130_ef_sc_hd__decap_12
XFILLER_95_429 VPWR VGND VPWR VGND sky130_ef_sc_hd__decap_12
XFILLER_84_41 VPWR VGND VPWR VGND sky130_ef_sc_hd__decap_12
XTAP_TAPCELL_ROW_59_885 VGND VPWR sky130_fd_sc_hd__tapvpwrvgnd_1
XFILLER_90_134 VGND VGND VPWR VPWR sky130_fd_sc_hd__decap_6
XFILLER_84_85 VGND VGND VPWR VPWR sky130_fd_sc_hd__decap_6
XFILLER_44_551 VPWR VGND VPWR VGND sky130_ef_sc_hd__decap_12
XFILLER_16_253 VPWR VGND VPWR VGND sky130_ef_sc_hd__decap_12
XFILLER_8_430 VGND VGND VPWR VPWR sky130_fd_sc_hd__decap_6
X_2750_ _2765_/A _2764_/B VGND VGND VPWR VPWR _2808_/B sky130_fd_sc_hd__nand2_1
X_2681_ _4526_/Q _2636_/B _2660_/A _2659_/Y VGND VGND VPWR VPWR _2681_/Y sky130_fd_sc_hd__a31oi_2
X_4420_ _4509_/CLK _4420_/D fanout130/X VGND VGND VPWR VPWR _4420_/Q sky130_fd_sc_hd__dfrtp_1
X_4351_ _3468_/A _3897_/A _4354_/A2 _4763_/Q VGND VGND VPWR VPWR _4763_/D sky130_fd_sc_hd__a2bb2o_1
XFILLER_98_245 VGND VGND VPWR VPWR sky130_fd_sc_hd__decap_6
X_3302_ _3303_/A _3303_/B VGND VGND VPWR VPWR _3325_/A sky130_fd_sc_hd__nand2_1
X_4282_ hold81/A hold20/A hold34/A _4398_/Q _2427_/A _2249_/B VGND VGND VPWR VPWR
+ _4283_/B sky130_fd_sc_hd__mux4_1
XFILLER_98_289 VPWR VGND VPWR VGND sky130_ef_sc_hd__decap_12
X_3233_ _3221_/A _3220_/B _3220_/A VGND VGND VPWR VPWR _3234_/B sky130_fd_sc_hd__a21bo_1
XFILLER_66_120 VGND VGND VPWR VPWR sky130_fd_sc_hd__fill_2
XFILLER_104_29 VPWR VGND VPWR VGND sky130_ef_sc_hd__decap_12
X_3164_ _3165_/A _3165_/B VGND VGND VPWR VPWR _3164_/X sky130_fd_sc_hd__and2b_1
XFILLER_66_131 VGND VGND VPWR VPWR sky130_fd_sc_hd__fill_1
XFILLER_39_356 VGND VGND VPWR VPWR sky130_fd_sc_hd__decap_6
XTAP_TAPCELL_ROW_107_1419 VGND VPWR sky130_fd_sc_hd__tapvpwrvgnd_1
XTAP_TAPCELL_ROW_107_1408 VGND VPWR sky130_fd_sc_hd__tapvpwrvgnd_1
XFILLER_82_613 VPWR VGND VPWR VGND sky130_ef_sc_hd__decap_12
X_3095_ _3095_/A _3095_/B VGND VGND VPWR VPWR _3096_/B sky130_fd_sc_hd__xnor2_2
XFILLER_39_389 VGND VGND VPWR VPWR sky130_fd_sc_hd__decap_3
XFILLER_81_167 VGND VGND VPWR VPWR sky130_fd_sc_hd__fill_1
Xfanout27 _2432_/X VGND VGND VPWR VPWR _2535_/A2 sky130_fd_sc_hd__clkbuf_2
Xfanout16 _3267_/Y VGND VGND VPWR VPWR _3915_/S0 sky130_fd_sc_hd__buf_4
Xfanout38 _2414_/B1 VGND VGND VPWR VPWR _2420_/B1 sky130_fd_sc_hd__buf_2
XFILLER_13_15 VPWR VGND VPWR VGND sky130_ef_sc_hd__decap_12
Xfanout49 _4028_/X VGND VGND VPWR VPWR _4138_/A1 sky130_fd_sc_hd__clkbuf_4
X_3997_ _4131_/D _4140_/B _4131_/B _4363_/Q VGND VGND VPWR VPWR _4030_/B sky130_fd_sc_hd__or4_4
X_2948_ _2922_/A _2922_/B _2922_/C _2915_/A VGND VGND VPWR VPWR _2949_/B sky130_fd_sc_hd__o31a_1
XTAP_TAPCELL_ROW_20_457 VGND VPWR sky130_fd_sc_hd__tapvpwrvgnd_1
X_4618_ _4684_/CLK _4618_/D fanout139/X VGND VGND VPWR VPWR hold41/A sky130_fd_sc_hd__dfrtp_1
X_2879_ _2879_/A _2879_/B VGND VGND VPWR VPWR _3676_/A sky130_fd_sc_hd__xnor2_4
XFILLER_104_501 VPWR VGND VPWR VGND sky130_ef_sc_hd__decap_12
X_4549_ _4552_/CLK _4549_/D fanout171/X VGND VGND VPWR VPWR _4549_/Q sky130_fd_sc_hd__dfrtp_4
XFILLER_1_105 VGND VGND VPWR VPWR sky130_fd_sc_hd__decap_6
XFILLER_104_545 VPWR VGND VPWR VGND sky130_ef_sc_hd__decap_12
XPHY_EDGE_ROW_8_Left_116 VGND VGND VPWR VPWR sky130_fd_sc_hd__decap_3
Xstream_cipher_184 VGND VGND VPWR VPWR stream_cipher_184/HI uio_out[6] sky130_fd_sc_hd__conb_1
XFILLER_104_589 VPWR VGND VPWR VGND sky130_ef_sc_hd__decap_12
XFILLER_89_278 VGND VGND VPWR VPWR sky130_fd_sc_hd__fill_2
XFILLER_85_473 VPWR VGND VPWR VGND sky130_ef_sc_hd__decap_12
XTAP_TAPCELL_ROW_28_535 VGND VPWR sky130_fd_sc_hd__tapvpwrvgnd_1
XTAP_TAPCELL_ROW_56_844 VGND VPWR sky130_fd_sc_hd__tapvpwrvgnd_1
XFILLER_60_307 VGND VGND VPWR VPWR sky130_fd_sc_hd__fill_1
XFILLER_60_329 VGND VGND VPWR VPWR sky130_fd_sc_hd__fill_1
XFILLER_13_212 VGND VGND VPWR VPWR sky130_fd_sc_hd__decap_4
XFILLER_13_256 VGND VGND VPWR VPWR sky130_fd_sc_hd__fill_1
XTAP_TAPCELL_ROW_97_1301 VGND VPWR sky130_fd_sc_hd__tapvpwrvgnd_1
XFILLER_70_65 VPWR VGND VPWR VGND sky130_ef_sc_hd__decap_12
Xclkload19 _4671_/CLK VGND VGND VPWR VPWR clkload19/Y sky130_fd_sc_hd__inv_6
XFILLER_107_361 VGND VGND VPWR VPWR sky130_fd_sc_hd__decap_3
XFILLER_95_237 VPWR VGND VPWR VGND sky130_ef_sc_hd__decap_12
XFILLER_95_51 VGND VGND VPWR VPWR sky130_fd_sc_hd__decap_4
XFILLER_64_613 VPWR VGND VPWR VGND sky130_ef_sc_hd__decap_12
XFILLER_48_186 VGND VGND VPWR VPWR sky130_fd_sc_hd__decap_8
XFILLER_17_540 VGND VGND VPWR VPWR sky130_fd_sc_hd__fill_1
XFILLER_48_197 VGND VGND VPWR VPWR sky130_fd_sc_hd__decap_3
X_3920_ _3920_/A _3920_/B VGND VGND VPWR VPWR _3926_/A sky130_fd_sc_hd__xor2_1
XFILLER_17_595 VGND VGND VPWR VPWR sky130_fd_sc_hd__decap_3
XTAP_TAPCELL_ROW_102_1349 VGND VPWR sky130_fd_sc_hd__tapvpwrvgnd_1
X_3851_ hold80/A hold98/A _4678_/Q hold46/A _3983_/S0 _3983_/S1 VGND VGND VPWR VPWR
+ _3853_/B sky130_fd_sc_hd__mux4_1
XFILLER_32_576 VPWR VGND VPWR VGND sky130_ef_sc_hd__decap_12
XFILLER_81_3 VPWR VGND VPWR VGND sky130_ef_sc_hd__decap_12
X_3782_ _3782_/A _3782_/B VGND VGND VPWR VPWR _3783_/B sky130_fd_sc_hd__nand2_1
X_2802_ _2325_/C _3592_/A _2983_/A2 _4501_/Q VGND VGND VPWR VPWR _4501_/D sky130_fd_sc_hd__a2bb2o_1
X_2733_ _2758_/A _2733_/B VGND VGND VPWR VPWR _2757_/A sky130_fd_sc_hd__nor2_4
X_2664_ _4495_/Q _2665_/B VGND VGND VPWR VPWR _2664_/X sky130_fd_sc_hd__and2_1
X_4403_ _4542_/CLK hold5/X fanout168/X VGND VGND VPWR VPWR _4403_/Q sky130_fd_sc_hd__dfrtp_1
X_2595_ _2595_/A _2595_/B VGND VGND VPWR VPWR _2601_/A sky130_fd_sc_hd__xor2_1
X_4334_ hold296/X _4339_/A2 _3475_/A _4339_/B2 VGND VGND VPWR VPWR _4746_/D sky130_fd_sc_hd__a22o_1
XTAP_TAPCELL_ROW_70_1006 VGND VPWR sky130_fd_sc_hd__tapvpwrvgnd_1
X_4265_ _4265_/A _4265_/B _4265_/C VGND VGND VPWR VPWR _4265_/X sky130_fd_sc_hd__and3_1
XFILLER_101_559 VGND VGND VPWR VPWR sky130_fd_sc_hd__fill_1
X_3216_ _4764_/Q _3195_/B _3198_/A VGND VGND VPWR VPWR _3221_/A sky130_fd_sc_hd__a21o_1
X_4196_ _4213_/A1 _4193_/X _4195_/Y _4217_/B1 hold271/X VGND VGND VPWR VPWR _4696_/D
+ sky130_fd_sc_hd__a32o_1
XFILLER_39_131 VGND VGND VPWR VPWR sky130_fd_sc_hd__fill_1
X_3147_ _4515_/Q _3148_/B VGND VGND VPWR VPWR _3147_/Y sky130_fd_sc_hd__nand2_1
XFILLER_39_175 VGND VGND VPWR VPWR sky130_fd_sc_hd__decap_3
XFILLER_82_421 VPWR VGND VPWR VGND sky130_ef_sc_hd__decap_12
XFILLER_27_337 VGND VGND VPWR VPWR sky130_fd_sc_hd__decap_8
XFILLER_39_197 VGND VGND VPWR VPWR sky130_fd_sc_hd__decap_3
X_3078_ _3054_/A _3054_/B _3051_/Y _3052_/Y _3106_/B VGND VGND VPWR VPWR _3100_/B
+ sky130_fd_sc_hd__a311o_1
XTAP_TAPCELL_ROW_25_505 VGND VPWR sky130_fd_sc_hd__tapvpwrvgnd_1
XTAP_TAPCELL_ROW_53_814 VGND VPWR sky130_fd_sc_hd__tapvpwrvgnd_1
XTAP_TAPCELL_ROW_81_1124 VGND VPWR sky130_fd_sc_hd__tapvpwrvgnd_1
XFILLER_6_208 VGND VGND VPWR VPWR sky130_fd_sc_hd__decap_6
XTAP_TAPCELL_ROW_33_593 VGND VPWR sky130_fd_sc_hd__tapvpwrvgnd_1
XTAP_TAPCELL_ROW_79_1097 VGND VPWR sky130_fd_sc_hd__tapvpwrvgnd_1
XTAP_TAPCELL_ROW_92_1242 VGND VPWR sky130_fd_sc_hd__tapvpwrvgnd_1
Xhold271 _4696_/Q VGND VGND VPWR VPWR hold271/X sky130_fd_sc_hd__dlygate4sd3_1
Xhold260 _4452_/Q VGND VGND VPWR VPWR hold260/X sky130_fd_sc_hd__dlygate4sd3_1
Xhold282 _4708_/Q VGND VGND VPWR VPWR hold282/X sky130_fd_sc_hd__dlygate4sd3_1
Xhold293 _4750_/Q VGND VGND VPWR VPWR hold293/X sky130_fd_sc_hd__dlygate4sd3_1
XFILLER_49_55 VGND VGND VPWR VPWR sky130_fd_sc_hd__fill_1
XFILLER_77_259 VGND VGND VPWR VPWR sky130_fd_sc_hd__decap_4
XFILLER_100_581 VGND VGND VPWR VPWR sky130_fd_sc_hd__decap_6
XTAP_TAPCELL_ROW_69_991 VGND VPWR sky130_fd_sc_hd__tapvpwrvgnd_1
XTAP_TAPCELL_ROW_5_285 VGND VPWR sky130_fd_sc_hd__tapvpwrvgnd_1
XFILLER_65_65 VGND VGND VPWR VPWR sky130_fd_sc_hd__decap_3
XFILLER_18_359 VGND VGND VPWR VPWR sky130_fd_sc_hd__decap_4
XFILLER_14_587 VGND VGND VPWR VPWR sky130_fd_sc_hd__fill_1
XFILLER_14_576 VGND VGND VPWR VPWR sky130_fd_sc_hd__fill_1
XFILLER_5_296 VGND VGND VPWR VPWR sky130_fd_sc_hd__decap_8
XFILLER_96_513 VPWR VGND VPWR VGND sky130_ef_sc_hd__decap_12
X_2380_ hold82/X _2407_/A2 _2407_/B1 _4545_/Q VGND VGND VPWR VPWR _4395_/D sky130_fd_sc_hd__a22o_1
XFILLER_96_557 VPWR VGND VPWR VGND sky130_ef_sc_hd__decap_12
XFILLER_68_248 VGND VGND VPWR VPWR sky130_fd_sc_hd__decap_4
X_4050_ _4131_/D _4140_/B _4113_/C _4068_/D VGND VGND VPWR VPWR _4058_/S sky130_fd_sc_hd__or4_4
XFILLER_49_440 VGND VGND VPWR VPWR sky130_fd_sc_hd__decap_8
Xinput6 ui_in[4] VGND VGND VPWR VPWR input6/X sky130_fd_sc_hd__clkbuf_1
X_3001_ _3000_/A _3000_/B _3027_/B VGND VGND VPWR VPWR _3556_/C sky130_fd_sc_hd__a21o_1
XFILLER_37_635 VGND VGND VPWR VPWR sky130_fd_sc_hd__fill_2
XFILLER_91_251 VGND VGND VPWR VPWR sky130_fd_sc_hd__fill_2
X_3903_ _3903_/A _3903_/B VGND VGND VPWR VPWR _3905_/A sky130_fd_sc_hd__nor2_1
X_3834_ _3834_/A _3834_/B VGND VGND VPWR VPWR _3836_/B sky130_fd_sc_hd__xor2_1
XFILLER_32_384 VPWR VGND VPWR VGND sky130_ef_sc_hd__decap_12
X_3765_ _4543_/Q _3765_/B VGND VGND VPWR VPWR _3767_/B sky130_fd_sc_hd__nor2_1
XTAP_TAPCELL_ROW_30_563 VGND VPWR sky130_fd_sc_hd__tapvpwrvgnd_1
X_2716_ _4744_/Q _2717_/B VGND VGND VPWR VPWR _2764_/A sky130_fd_sc_hd__nand2_1
X_3696_ _3696_/A _3826_/A VGND VGND VPWR VPWR _3698_/B sky130_fd_sc_hd__xnor2_1
X_2647_ _2644_/A _2644_/B _2641_/X VGND VGND VPWR VPWR _2667_/A sky130_fd_sc_hd__a21o_2
XFILLER_10_27 VGND VGND VPWR VPWR sky130_fd_sc_hd__fill_1
X_2578_ _4490_/Q _3277_/B2 _3272_/A _4331_/B2 VGND VGND VPWR VPWR _4490_/D sky130_fd_sc_hd__a22o_1
XFILLER_59_204 VPWR VGND VPWR VGND sky130_ef_sc_hd__decap_12
XFILLER_99_373 VPWR VGND VPWR VGND sky130_ef_sc_hd__decap_12
X_4317_ _4379_/Q hold22/A hold82/A _4403_/Q _4436_/Q _4437_/Q VGND VGND VPWR VPWR
+ _4318_/B sky130_fd_sc_hd__mux4_1
XFILLER_59_237 VPWR VGND VPWR VGND sky130_ef_sc_hd__decap_12
XPHY_EDGE_ROW_98_Left_206 VGND VGND VPWR VPWR sky130_fd_sc_hd__decap_3
X_4248_ _4710_/Q _4709_/Q _4239_/B _4711_/Q VGND VGND VPWR VPWR _4248_/X sky130_fd_sc_hd__a31o_1
XFILLER_19_69 VPWR VGND VPWR VGND sky130_ef_sc_hd__decap_12
XFILLER_67_281 VPWR VGND VPWR VGND sky130_ef_sc_hd__decap_12
XTAP_TAPCELL_ROW_2_255 VGND VPWR sky130_fd_sc_hd__tapvpwrvgnd_1
X_4179_ _4213_/A1 _4177_/Y _4178_/X _4217_/B1 hold283/X VGND VGND VPWR VPWR _4691_/D
+ sky130_fd_sc_hd__a32o_1
XFILLER_55_443 VGND VGND VPWR VPWR sky130_fd_sc_hd__decap_4
XTAP_TAPCELL_ROW_66_961 VGND VPWR sky130_fd_sc_hd__tapvpwrvgnd_1
XFILLER_27_167 VGND VGND VPWR VPWR sky130_fd_sc_hd__fill_1
XTAP_TAPCELL_ROW_38_652 VGND VPWR sky130_fd_sc_hd__tapvpwrvgnd_1
XFILLER_35_57 VPWR VGND VPWR VGND sky130_ef_sc_hd__decap_12
XFILLER_11_513 VPWR VGND VPWR VGND sky130_ef_sc_hd__decap_12
XFILLER_23_362 VPWR VGND VPWR VGND sky130_ef_sc_hd__decap_12
Xclkbuf_3_3__f_clk clkbuf_0_clk/X VGND VGND VPWR VPWR clkload3/A sky130_fd_sc_hd__clkbuf_16
XPHY_EDGE_ROW_14_Right_14 VGND VGND VPWR VPWR sky130_fd_sc_hd__decap_3
XFILLER_78_513 VPWR VGND VPWR VGND sky130_ef_sc_hd__decap_12
XPHY_EDGE_ROW_23_Right_23 VGND VGND VPWR VPWR sky130_fd_sc_hd__decap_3
XFILLER_93_505 VPWR VGND VPWR VGND sky130_ef_sc_hd__decap_12
XFILLER_78_557 VPWR VGND VPWR VGND sky130_ef_sc_hd__decap_12
XFILLER_76_53 VPWR VGND VPWR VGND sky130_ef_sc_hd__decap_12
XFILLER_46_421 VGND VGND VPWR VPWR sky130_fd_sc_hd__decap_4
XFILLER_73_251 VGND VGND VPWR VPWR sky130_fd_sc_hd__decap_4
XFILLER_73_240 VGND VGND VPWR VPWR sky130_fd_sc_hd__decap_4
XFILLER_92_41 VPWR VGND VPWR VGND sky130_ef_sc_hd__decap_12
XFILLER_92_85 VPWR VGND VPWR VGND sky130_ef_sc_hd__decap_12
XPHY_EDGE_ROW_32_Right_32 VGND VGND VPWR VPWR sky130_fd_sc_hd__decap_3
XFILLER_14_362 VGND VGND VPWR VPWR sky130_fd_sc_hd__fill_2
X_3550_ _3550_/A _3550_/B VGND VGND VPWR VPWR _3551_/B sky130_fd_sc_hd__xnor2_2
XFILLER_6_550 VGND VGND VPWR VPWR sky130_fd_sc_hd__fill_1
X_2501_ _4462_/Q _4461_/Q _2501_/C VGND VGND VPWR VPWR _2505_/B sky130_fd_sc_hd__and3_1
XFILLER_6_583 VGND VGND VPWR VPWR sky130_fd_sc_hd__decap_4
X_3481_ _3481_/A _3696_/A VGND VGND VPWR VPWR _3483_/B sky130_fd_sc_hd__xnor2_2
XFILLER_102_109 VPWR VGND VPWR VGND sky130_ef_sc_hd__decap_12
X_2432_ _2432_/A _2558_/B VGND VGND VPWR VPWR _2432_/X sky130_fd_sc_hd__or2_2
XPHY_EDGE_ROW_41_Right_41 VGND VGND VPWR VPWR sky130_fd_sc_hd__decap_3
XFILLER_44_3 VPWR VGND VPWR VGND sky130_ef_sc_hd__decap_12
XFILLER_96_321 VPWR VGND VPWR VGND sky130_ef_sc_hd__decap_12
X_2363_ hold37/X _4262_/A _4256_/A1 _4528_/Q VGND VGND VPWR VPWR _4378_/D sky130_fd_sc_hd__a22o_1
X_4102_ _4013_/B _4094_/B _4138_/A1 _4094_/Y hold67/X VGND VGND VPWR VPWR _4635_/D
+ sky130_fd_sc_hd__a32o_1
XFILLER_96_365 VPWR VGND VPWR VGND sky130_ef_sc_hd__decap_12
X_2294_ _4688_/Q _2442_/A _4689_/Q _2188_/Y _2293_/X VGND VGND VPWR VPWR _2294_/X
+ sky130_fd_sc_hd__o221a_1
X_4033_ _4132_/A1 hold134/X _4040_/S VGND VGND VPWR VPWR _4573_/D sky130_fd_sc_hd__mux2_1
XFILLER_2_83 VGND VGND VPWR VPWR sky130_fd_sc_hd__fill_1
XFILLER_49_281 VPWR VGND VPWR VGND sky130_ef_sc_hd__decap_12
XFILLER_64_284 VGND VGND VPWR VPWR sky130_fd_sc_hd__decap_4
XTAP_TAPCELL_ROW_63_920 VGND VPWR sky130_fd_sc_hd__tapvpwrvgnd_1
XTAP_TAPCELL_ROW_35_622 VGND VPWR sky130_fd_sc_hd__tapvpwrvgnd_1
XPHY_EDGE_ROW_50_Right_50 VGND VGND VPWR VPWR sky130_fd_sc_hd__decap_3
XFILLER_32_170 VGND VGND VPWR VPWR sky130_fd_sc_hd__decap_3
X_3817_ _3817_/A _3817_/B VGND VGND VPWR VPWR _3818_/B sky130_fd_sc_hd__or2_1
XFILLER_20_365 VPWR VGND VPWR VGND sky130_ef_sc_hd__decap_12
X_3748_ _3769_/B _3747_/Y _4542_/Q _3748_/B2 VGND VGND VPWR VPWR _4542_/D sky130_fd_sc_hd__a2bb2o_1
XFILLER_21_15 VPWR VGND VPWR VGND sky130_ef_sc_hd__decap_12
X_3679_ _3677_/B _3677_/C _3780_/A VGND VGND VPWR VPWR _3679_/X sky130_fd_sc_hd__a21o_1
XTAP_TAPCELL_ROW_76_1067 VGND VPWR sky130_fd_sc_hd__tapvpwrvgnd_1
XTAP_TAPCELL_ROW_7_314 VGND VPWR sky130_fd_sc_hd__tapvpwrvgnd_1
XFILLER_99_181 VPWR VGND VPWR VGND sky130_ef_sc_hd__decap_12
XFILLER_87_332 VGND VGND VPWR VPWR sky130_fd_sc_hd__decap_4
XFILLER_75_505 VPWR VGND VPWR VGND sky130_ef_sc_hd__decap_12
XFILLER_28_421 VGND VGND VPWR VPWR sky130_fd_sc_hd__decap_4
XTAP_TAPCELL_ROW_87_1185 VGND VPWR sky130_fd_sc_hd__tapvpwrvgnd_1
XFILLER_70_210 VGND VGND VPWR VPWR sky130_fd_sc_hd__fill_2
XFILLER_31_608 VGND VGND VPWR VPWR sky130_fd_sc_hd__fill_2
XFILLER_43_468 VGND VGND VPWR VPWR sky130_fd_sc_hd__decap_4
XFILLER_70_276 VGND VGND VPWR VPWR sky130_fd_sc_hd__fill_2
XFILLER_62_77 VGND VGND VPWR VPWR sky130_fd_sc_hd__decap_6
XFILLER_11_310 VPWR VGND VPWR VGND sky130_ef_sc_hd__decap_12
Xclkbuf_leaf_50_clk clkload1/A VGND VGND VPWR VPWR _4499_/CLK sky130_fd_sc_hd__clkbuf_8
XFILLER_23_181 VGND VGND VPWR VPWR sky130_fd_sc_hd__fill_1
XFILLER_11_354 VPWR VGND VPWR VGND sky130_ef_sc_hd__decap_12
XFILLER_7_39 VPWR VGND VPWR VGND sky130_ef_sc_hd__decap_12
XFILLER_11_81 VGND VGND VPWR VPWR sky130_fd_sc_hd__decap_4
XFILLER_3_597 VGND VGND VPWR VPWR sky130_fd_sc_hd__decap_6
XFILLER_78_365 VPWR VGND VPWR VGND sky130_ef_sc_hd__decap_12
XFILLER_46_240 VGND VGND VPWR VPWR sky130_fd_sc_hd__decap_4
XTAP_TAPCELL_ROW_49_769 VGND VPWR sky130_fd_sc_hd__tapvpwrvgnd_1
XFILLER_34_435 VGND VGND VPWR VPWR sky130_fd_sc_hd__fill_2
XFILLER_46_295 VPWR VGND VPWR VGND sky130_ef_sc_hd__decap_12
X_2981_ _3027_/A _2981_/B _2981_/C VGND VGND VPWR VPWR _2982_/B sky130_fd_sc_hd__nand3_1
Xclkbuf_leaf_41_clk _4459_/CLK VGND VGND VPWR VPWR _4693_/CLK sky130_fd_sc_hd__clkbuf_8
X_4720_ _4735_/CLK _4720_/D fanout148/X VGND VGND VPWR VPWR uo_out[1] sky130_fd_sc_hd__dfrtp_4
X_4651_ _4684_/CLK _4651_/D fanout139/X VGND VGND VPWR VPWR _4651_/Q sky130_fd_sc_hd__dfrtp_1
XTAP_TAPCELL_ROW_12_360 VGND VPWR sky130_fd_sc_hd__tapvpwrvgnd_1
X_3602_ _3602_/A VGND VGND VPWR VPWR _3603_/B sky130_fd_sc_hd__inv_2
X_4582_ _4758_/CLK _4582_/D fanout140/X VGND VGND VPWR VPWR hold98/A sky130_fd_sc_hd__dfrtp_1
X_3533_ _3533_/A _3533_/B VGND VGND VPWR VPWR _3534_/B sky130_fd_sc_hd__or2_1
XFILLER_107_29 VGND VGND VPWR VPWR sky130_fd_sc_hd__fill_1
X_3464_ _4531_/Q _3465_/B VGND VGND VPWR VPWR _3464_/X sky130_fd_sc_hd__xor2_1
XFILLER_103_429 VPWR VGND VPWR VGND sky130_ef_sc_hd__decap_12
X_2415_ _4430_/Q _2420_/A2 _2420_/B1 hold291/X VGND VGND VPWR VPWR _4430_/D sky130_fd_sc_hd__a22o_1
XFILLER_69_321 VPWR VGND VPWR VGND sky130_ef_sc_hd__decap_12
X_3395_ _3415_/B _3395_/B VGND VGND VPWR VPWR _3402_/A sky130_fd_sc_hd__nand2_1
X_2346_ _4068_/B _2347_/C VGND VGND VPWR VPWR _4361_/D sky130_fd_sc_hd__xnor2_1
XFILLER_57_505 VPWR VGND VPWR VGND sky130_ef_sc_hd__decap_12
XFILLER_96_195 VGND VGND VPWR VPWR sky130_fd_sc_hd__fill_1
X_2277_ _4708_/Q _2509_/A _4707_/Q _2209_/Y VGND VGND VPWR VPWR _2277_/X sky130_fd_sc_hd__o22a_1
X_4016_ _4363_/Q _4016_/B VGND VGND VPWR VPWR _4016_/Y sky130_fd_sc_hd__nand2b_4
XFILLER_16_15 VPWR VGND VPWR VGND sky130_ef_sc_hd__decap_12
XFILLER_25_424 VGND VGND VPWR VPWR sky130_fd_sc_hd__decap_6
XFILLER_25_457 VGND VGND VPWR VPWR sky130_fd_sc_hd__decap_8
XFILLER_52_221 VGND VGND VPWR VPWR sky130_fd_sc_hd__decap_3
Xclkbuf_leaf_32_clk _4459_/CLK VGND VGND VPWR VPWR _4726_/CLK sky130_fd_sc_hd__clkbuf_8
XFILLER_106_245 VGND VGND VPWR VPWR sky130_fd_sc_hd__decap_6
XFILLER_106_289 VPWR VGND VPWR VGND sky130_ef_sc_hd__decap_12
XFILLER_0_523 VGND VGND VPWR VPWR sky130_fd_sc_hd__decap_8
XFILLER_0_545 VPWR VGND VPWR VGND sky130_ef_sc_hd__decap_12
XFILLER_0_589 VPWR VGND VPWR VGND sky130_ef_sc_hd__decap_12
XTAP_TAPCELL_ROW_89_1214 VGND VPWR sky130_fd_sc_hd__tapvpwrvgnd_1
XFILLER_57_55 VGND VGND VPWR VPWR sky130_fd_sc_hd__fill_1
XFILLER_90_316 VPWR VGND VPWR VGND sky130_ef_sc_hd__decap_12
XTAP_TAPCELL_ROW_46_739 VGND VPWR sky130_fd_sc_hd__tapvpwrvgnd_1
XFILLER_83_390 VGND VGND VPWR VPWR sky130_fd_sc_hd__fill_2
XFILLER_71_541 VPWR VGND VPWR VGND sky130_ef_sc_hd__decap_12
XFILLER_71_585 VPWR VGND VPWR VGND sky130_ef_sc_hd__decap_12
Xclkbuf_leaf_23_clk clkload5/A VGND VGND VPWR VPWR _4547_/CLK sky130_fd_sc_hd__clkbuf_8
XFILLER_31_427 VGND VGND VPWR VPWR sky130_fd_sc_hd__fill_1
XFILLER_11_151 VGND VGND VPWR VPWR sky130_fd_sc_hd__decap_3
XFILLER_7_111 VGND VGND VPWR VPWR sky130_fd_sc_hd__fill_1
XFILLER_3_361 VGND VGND VPWR VPWR sky130_fd_sc_hd__decap_8
X_2200_ _4471_/Q VGND VGND VPWR VPWR _2200_/Y sky130_fd_sc_hd__inv_2
X_3180_ _3197_/B _3180_/B VGND VGND VPWR VPWR _3186_/A sky130_fd_sc_hd__nand2_1
XFILLER_93_121 VPWR VGND VPWR VGND sky130_ef_sc_hd__decap_12
XFILLER_78_195 VGND VGND VPWR VPWR sky130_fd_sc_hd__fill_1
XFILLER_39_549 VGND VGND VPWR VPWR sky130_fd_sc_hd__decap_3
XFILLER_81_349 VGND VGND VPWR VPWR sky130_fd_sc_hd__fill_2
X_2964_ _2905_/A _2937_/Y _2939_/B VGND VGND VPWR VPWR _2965_/A sky130_fd_sc_hd__o21ai_1
Xclkbuf_leaf_14_clk clkload2/A VGND VGND VPWR VPWR _4684_/CLK sky130_fd_sc_hd__clkbuf_8
X_4703_ _4706_/CLK _4703_/D fanout161/X VGND VGND VPWR VPWR _4703_/Q sky130_fd_sc_hd__dfrtp_1
X_2895_ _4505_/Q _2897_/B VGND VGND VPWR VPWR _2898_/A sky130_fd_sc_hd__nand2_1
X_4634_ _4667_/CLK _4634_/D fanout125/X VGND VGND VPWR VPWR hold73/A sky130_fd_sc_hd__dfrtp_1
X_4565_ _4667_/CLK _4565_/D fanout124/X VGND VGND VPWR VPWR _4565_/Q sky130_fd_sc_hd__dfrtp_1
X_3516_ _3476_/B _3516_/B VGND VGND VPWR VPWR _3517_/B sky130_fd_sc_hd__nand2b_1
XTAP_TAPCELL_ROW_73_1037 VGND VPWR sky130_fd_sc_hd__tapvpwrvgnd_1
XPHY_EDGE_ROW_4_Right_4 VGND VGND VPWR VPWR sky130_fd_sc_hd__decap_3
X_4496_ _4499_/CLK _4496_/D fanout132/X VGND VGND VPWR VPWR _4496_/Q sky130_fd_sc_hd__dfrtp_4
XFILLER_103_237 VPWR VGND VPWR VGND sky130_ef_sc_hd__decap_12
XFILLER_89_449 VPWR VGND VPWR VGND sky130_ef_sc_hd__decap_12
X_3447_ _3448_/A _3448_/B VGND VGND VPWR VPWR _3447_/X sky130_fd_sc_hd__or2_1
X_3378_ _3378_/A _3378_/B _3378_/C VGND VGND VPWR VPWR _3380_/B sky130_fd_sc_hd__or3_1
X_2329_ input2/X _4718_/D VGND VGND VPWR VPWR _4728_/D sky130_fd_sc_hd__and2_1
XFILLER_57_335 VGND VGND VPWR VPWR sky130_fd_sc_hd__fill_1
XPHY_EDGE_ROW_71_Left_179 VGND VGND VPWR VPWR sky130_fd_sc_hd__decap_3
XFILLER_27_69 VPWR VGND VPWR VGND sky130_ef_sc_hd__decap_12
XTAP_TAPCELL_ROW_84_1155 VGND VPWR sky130_fd_sc_hd__tapvpwrvgnd_1
XTAP_TAPCELL_ROW_43_709 VGND VPWR sky130_fd_sc_hd__tapvpwrvgnd_1
XFILLER_53_585 VGND VGND VPWR VPWR sky130_fd_sc_hd__decap_8
XFILLER_13_449 VGND VGND VPWR VPWR sky130_fd_sc_hd__decap_3
XFILLER_43_57 VPWR VGND VPWR VGND sky130_ef_sc_hd__decap_12
XPHY_EDGE_ROW_80_Left_188 VGND VGND VPWR VPWR sky130_fd_sc_hd__decap_3
XTAP_TAPCELL_ROW_23_488 VGND VPWR sky130_fd_sc_hd__tapvpwrvgnd_1
XTAP_TAPCELL_ROW_51_797 VGND VPWR sky130_fd_sc_hd__tapvpwrvgnd_1
XTAP_TAPCELL_ROW_95_1273 VGND VPWR sky130_fd_sc_hd__tapvpwrvgnd_1
XFILLER_4_29 VPWR VGND VPWR VGND sky130_ef_sc_hd__decap_12
XFILLER_68_65 VPWR VGND VPWR VGND sky130_ef_sc_hd__decap_12
XFILLER_75_121 VGND VGND VPWR VPWR sky130_fd_sc_hd__decap_6
XFILLER_84_53 VPWR VGND VPWR VGND sky130_ef_sc_hd__decap_12
XFILLER_75_187 VGND VGND VPWR VPWR sky130_fd_sc_hd__decap_6
XFILLER_63_305 VGND VGND VPWR VPWR sky130_fd_sc_hd__decap_3
XTAP_TAPCELL_ROW_59_886 VGND VPWR sky130_fd_sc_hd__tapvpwrvgnd_1
XFILLER_16_265 VGND VGND VPWR VPWR sky130_fd_sc_hd__decap_6
XFILLER_44_563 VGND VGND VPWR VPWR sky130_fd_sc_hd__fill_1
XFILLER_71_393 VGND VGND VPWR VPWR sky130_fd_sc_hd__decap_4
XTAP_TAPCELL_ROW_104_1380 VGND VPWR sky130_fd_sc_hd__tapvpwrvgnd_1
X_2680_ _2680_/A _2680_/B VGND VGND VPWR VPWR _2683_/A sky130_fd_sc_hd__nand2_1
X_4350_ _3468_/A _3876_/A _4354_/A2 _4762_/Q VGND VGND VPWR VPWR _4762_/D sky130_fd_sc_hd__a2bb2o_1
X_3301_ _4623_/Q _4559_/Q hold86/A _4591_/Q _3569_/S0 _3283_/S VGND VGND VPWR VPWR
+ _3303_/B sky130_fd_sc_hd__mux4_1
X_4281_ uo_out[1] _4280_/Y _4323_/S VGND VGND VPWR VPWR _4720_/D sky130_fd_sc_hd__mux2_1
X_3232_ _3230_/X _3232_/B VGND VGND VPWR VPWR _3234_/A sky130_fd_sc_hd__nand2b_1
XFILLER_86_419 VGND VGND VPWR VPWR sky130_fd_sc_hd__fill_1
Xclkbuf_leaf_3_clk clkload0/A VGND VGND VPWR VPWR clkload8/A sky130_fd_sc_hd__clkbuf_8
X_3163_ _3145_/A _3142_/A _3144_/B VGND VGND VPWR VPWR _3165_/B sky130_fd_sc_hd__a21oi_1
XTAP_TAPCELL_ROW_107_1409 VGND VPWR sky130_fd_sc_hd__tapvpwrvgnd_1
XFILLER_82_625 VPWR VGND VPWR VGND sky130_ef_sc_hd__decap_12
XFILLER_81_113 VPWR VGND VPWR VGND sky130_ef_sc_hd__decap_12
X_3094_ _3122_/A _3094_/B VGND VGND VPWR VPWR _3095_/B sky130_fd_sc_hd__or2_1
XFILLER_35_530 VGND VGND VPWR VPWR sky130_fd_sc_hd__decap_3
Xfanout17 _3267_/Y VGND VGND VPWR VPWR _3983_/S0 sky130_fd_sc_hd__buf_2
Xfanout28 _4015_/X VGND VGND VPWR VPWR _4016_/B sky130_fd_sc_hd__clkbuf_4
X_3996_ _3993_/Y _3995_/X _2328_/B VGND VGND VPWR VPWR _3996_/Y sky130_fd_sc_hd__a21oi_1
Xfanout39 _4265_/B VGND VGND VPWR VPWR _2414_/B1 sky130_fd_sc_hd__buf_2
XFILLER_13_27 VPWR VGND VPWR VGND sky130_ef_sc_hd__decap_12
XFILLER_10_419 VGND VGND VPWR VPWR sky130_fd_sc_hd__fill_1
X_2947_ _2947_/A _2947_/B VGND VGND VPWR VPWR _3014_/A sky130_fd_sc_hd__nand2_1
XTAP_TAPCELL_ROW_20_447 VGND VPWR sky130_fd_sc_hd__tapvpwrvgnd_1
X_4617_ _4684_/CLK _4617_/D fanout141/X VGND VGND VPWR VPWR hold44/A sky130_fd_sc_hd__dfrtp_1
X_2878_ _2878_/A _2878_/B _2878_/C VGND VGND VPWR VPWR _2879_/B sky130_fd_sc_hd__nand3_2
XFILLER_104_513 VPWR VGND VPWR VGND sky130_ef_sc_hd__decap_12
X_4548_ clkload5/A _4548_/D fanout171/X VGND VGND VPWR VPWR hold28/A sky130_fd_sc_hd__dfrtp_4
XFILLER_104_557 VPWR VGND VPWR VGND sky130_ef_sc_hd__decap_12
X_4479_ _4716_/CLK _4479_/D fanout162/X VGND VGND VPWR VPWR _4479_/Q sky130_fd_sc_hd__dfrtp_1
Xstream_cipher_174 VGND VGND VPWR VPWR stream_cipher_174/HI uio_oe[0] sky130_fd_sc_hd__conb_1
Xstream_cipher_185 VGND VGND VPWR VPWR stream_cipher_185/HI uio_out[7] sky130_fd_sc_hd__conb_1
XFILLER_85_485 VPWR VGND VPWR VGND sky130_ef_sc_hd__decap_12
XPHY_EDGE_ROW_79_Right_79 VGND VGND VPWR VPWR sky130_fd_sc_hd__decap_3
XTAP_TAPCELL_ROW_28_536 VGND VPWR sky130_fd_sc_hd__tapvpwrvgnd_1
XTAP_TAPCELL_ROW_56_845 VGND VPWR sky130_fd_sc_hd__tapvpwrvgnd_1
XFILLER_53_393 VPWR VGND VPWR VGND sky130_ef_sc_hd__decap_12
XFILLER_9_228 VPWR VGND VPWR VGND sky130_ef_sc_hd__decap_12
XTAP_TAPCELL_ROW_97_1302 VGND VPWR sky130_fd_sc_hd__tapvpwrvgnd_1
XFILLER_70_77 VGND VGND VPWR VPWR sky130_fd_sc_hd__decap_6
XPHY_EDGE_ROW_88_Right_88 VGND VGND VPWR VPWR sky130_fd_sc_hd__decap_3
XFILLER_95_205 VPWR VGND VPWR VGND sky130_ef_sc_hd__decap_12
XFILLER_68_419 VGND VGND VPWR VPWR sky130_fd_sc_hd__fill_1
XFILLER_48_110 VGND VGND VPWR VPWR sky130_fd_sc_hd__fill_1
XPHY_EDGE_ROW_97_Right_97 VGND VGND VPWR VPWR sky130_fd_sc_hd__decap_3
XFILLER_95_249 VPWR VGND VPWR VGND sky130_ef_sc_hd__decap_12
XFILLER_88_290 VPWR VGND VPWR VGND sky130_ef_sc_hd__decap_12
XFILLER_64_625 VPWR VGND VPWR VGND sky130_ef_sc_hd__decap_12
XFILLER_32_511 VGND VGND VPWR VPWR sky130_fd_sc_hd__fill_1
XFILLER_44_360 VGND VGND VPWR VPWR sky130_fd_sc_hd__decap_4
X_3850_ _3814_/A _3849_/Y _3872_/B VGND VGND VPWR VPWR _3853_/A sky130_fd_sc_hd__o21ai_1
X_3781_ _3782_/A _3782_/B VGND VGND VPWR VPWR _3783_/A sky130_fd_sc_hd__or2_1
X_2801_ _2831_/C _2801_/B VGND VGND VPWR VPWR _3592_/A sky130_fd_sc_hd__xor2_4
XFILLER_74_3 VPWR VGND VPWR VGND sky130_ef_sc_hd__decap_12
X_2732_ _4498_/Q _2732_/B VGND VGND VPWR VPWR _2733_/B sky130_fd_sc_hd__nor2_1
X_2663_ _2663_/A _2663_/B VGND VGND VPWR VPWR _2665_/B sky130_fd_sc_hd__xnor2_1
X_4402_ _4542_/CLK _4402_/D fanout168/X VGND VGND VPWR VPWR _4402_/Q sky130_fd_sc_hd__dfrtp_1
X_2594_ _2592_/X _2594_/B VGND VGND VPWR VPWR _2595_/B sky130_fd_sc_hd__nand2b_1
X_4333_ _4745_/Q _4339_/A2 _3459_/A _4339_/B2 VGND VGND VPWR VPWR _4745_/D sky130_fd_sc_hd__a22o_1
XFILLER_101_505 VPWR VGND VPWR VGND sky130_ef_sc_hd__decap_12
XTAP_TAPCELL_ROW_70_1007 VGND VPWR sky130_fd_sc_hd__tapvpwrvgnd_1
XFILLER_59_419 VPWR VGND VPWR VGND sky130_ef_sc_hd__decap_12
X_4264_ _4264_/A _4264_/B VGND VGND VPWR VPWR _4715_/D sky130_fd_sc_hd__and2_1
X_3215_ _3215_/A _3215_/B VGND VGND VPWR VPWR _3222_/A sky130_fd_sc_hd__xnor2_1
XFILLER_39_110 VGND VGND VPWR VPWR sky130_fd_sc_hd__fill_2
X_4195_ _4197_/B VGND VGND VPWR VPWR _4195_/Y sky130_fd_sc_hd__inv_2
X_3146_ _3146_/A _3146_/B VGND VGND VPWR VPWR _3148_/B sky130_fd_sc_hd__xnor2_1
XFILLER_82_433 VPWR VGND VPWR VGND sky130_ef_sc_hd__decap_12
X_3077_ _3054_/A _3054_/B _3051_/Y _3052_/Y VGND VGND VPWR VPWR _3079_/B sky130_fd_sc_hd__a31o_1
XFILLER_82_477 VPWR VGND VPWR VGND sky130_ef_sc_hd__decap_12
XTAP_TAPCELL_ROW_25_506 VGND VPWR sky130_fd_sc_hd__tapvpwrvgnd_1
XTAP_TAPCELL_ROW_53_815 VGND VPWR sky130_fd_sc_hd__tapvpwrvgnd_1
XFILLER_24_15 VPWR VGND VPWR VGND sky130_ef_sc_hd__decap_12
XFILLER_35_360 VPWR VGND VPWR VGND sky130_ef_sc_hd__decap_12
XTAP_TAPCELL_ROW_81_1125 VGND VPWR sky130_fd_sc_hd__tapvpwrvgnd_1
XFILLER_35_393 VPWR VGND VPWR VGND sky130_ef_sc_hd__decap_12
XFILLER_50_341 VPWR VGND VPWR VGND sky130_ef_sc_hd__decap_12
X_3979_ _3976_/Y _3978_/Y _4552_/Q _3979_/B2 VGND VGND VPWR VPWR _4552_/D sky130_fd_sc_hd__a2bb2o_1
XTAP_TAPCELL_ROW_33_594 VGND VPWR sky130_fd_sc_hd__tapvpwrvgnd_1
XTAP_TAPCELL_ROW_79_1098 VGND VPWR sky130_fd_sc_hd__tapvpwrvgnd_1
XFILLER_104_321 VPWR VGND VPWR VGND sky130_ef_sc_hd__decap_12
XTAP_TAPCELL_ROW_92_1243 VGND VPWR sky130_fd_sc_hd__tapvpwrvgnd_1
Xhold250 _4515_/Q VGND VGND VPWR VPWR hold250/X sky130_fd_sc_hd__dlygate4sd3_1
Xhold261 _4692_/Q VGND VGND VPWR VPWR hold261/X sky130_fd_sc_hd__dlygate4sd3_1
XFILLER_104_365 VPWR VGND VPWR VGND sky130_ef_sc_hd__decap_12
Xhold294 _4654_/Q VGND VGND VPWR VPWR hold294/X sky130_fd_sc_hd__dlygate4sd3_1
Xhold283 _4691_/Q VGND VGND VPWR VPWR hold283/X sky130_fd_sc_hd__dlygate4sd3_1
Xhold272 _4686_/Q VGND VGND VPWR VPWR hold272/X sky130_fd_sc_hd__dlygate4sd3_1
XFILLER_105_51 VGND VGND VPWR VPWR sky130_fd_sc_hd__decap_4
XFILLER_85_271 VGND VGND VPWR VPWR sky130_fd_sc_hd__decap_8
XFILLER_85_260 VGND VGND VPWR VPWR sky130_fd_sc_hd__decap_4
XTAP_TAPCELL_ROW_5_286 VGND VPWR sky130_fd_sc_hd__tapvpwrvgnd_1
XFILLER_18_316 VGND VGND VPWR VPWR sky130_fd_sc_hd__fill_2
XTAP_TAPCELL_ROW_69_992 VGND VPWR sky130_fd_sc_hd__tapvpwrvgnd_1
XFILLER_65_55 VGND VGND VPWR VPWR sky130_fd_sc_hd__fill_1
XFILLER_46_636 VGND VGND VPWR VPWR sky130_fd_sc_hd__fill_1
XFILLER_61_617 VPWR VGND VPWR VGND sky130_ef_sc_hd__decap_12
XFILLER_107_181 VPWR VGND VPWR VGND sky130_ef_sc_hd__decap_12
XFILLER_96_525 VGND VGND VPWR VPWR sky130_fd_sc_hd__decap_6
XFILLER_68_205 VGND VGND VPWR VPWR sky130_fd_sc_hd__fill_2
XFILLER_1_470 VGND VGND VPWR VPWR sky130_fd_sc_hd__decap_3
XFILLER_96_569 VPWR VGND VPWR VGND sky130_ef_sc_hd__decap_12
XFILLER_76_260 VGND VGND VPWR VPWR sky130_fd_sc_hd__fill_1
Xinput7 ui_in[5] VGND VGND VPWR VPWR input7/X sky130_fd_sc_hd__clkbuf_1
XFILLER_37_603 VGND VGND VPWR VPWR sky130_fd_sc_hd__decap_4
X_3000_ _3000_/A _3000_/B _3027_/B VGND VGND VPWR VPWR _3556_/B sky130_fd_sc_hd__nand3_1
XFILLER_64_477 VPWR VGND VPWR VGND sky130_ef_sc_hd__decap_12
XFILLER_17_382 VGND VGND VPWR VPWR sky130_fd_sc_hd__fill_1
XFILLER_36_179 VGND VGND VPWR VPWR sky130_fd_sc_hd__decap_3
X_3902_ _3902_/A _3987_/A VGND VGND VPWR VPWR _3903_/B sky130_fd_sc_hd__and2_1
XFILLER_17_393 VGND VGND VPWR VPWR sky130_fd_sc_hd__fill_1
XFILLER_44_190 VGND VGND VPWR VPWR sky130_fd_sc_hd__decap_3
X_3833_ _3833_/A _3833_/B VGND VGND VPWR VPWR _3834_/B sky130_fd_sc_hd__xnor2_1
XFILLER_20_547 VGND VGND VPWR VPWR sky130_fd_sc_hd__fill_1
XFILLER_32_396 VGND VGND VPWR VPWR sky130_fd_sc_hd__decap_3
X_3764_ _4543_/Q _3765_/B VGND VGND VPWR VPWR _3767_/A sky130_fd_sc_hd__and2_1
XTAP_TAPCELL_ROW_30_564 VGND VPWR sky130_fd_sc_hd__tapvpwrvgnd_1
X_3695_ _3679_/X _3683_/B _3735_/A VGND VGND VPWR VPWR _3710_/A sky130_fd_sc_hd__a21o_1
X_2715_ _4565_/Q _4597_/Q _4629_/Q _4661_/Q _2746_/S _2747_/A VGND VGND VPWR VPWR
+ _2717_/B sky130_fd_sc_hd__mux4_2
X_2646_ hold301/X _3277_/B2 _3438_/A _2708_/B2 VGND VGND VPWR VPWR _4494_/D sky130_fd_sc_hd__a22o_1
XFILLER_87_503 VGND VGND VPWR VPWR sky130_fd_sc_hd__fill_1
X_2577_ _2588_/A _2577_/B VGND VGND VPWR VPWR _3272_/A sky130_fd_sc_hd__and2_1
XFILLER_99_385 VGND VGND VPWR VPWR sky130_fd_sc_hd__decap_6
X_4316_ uo_out[6] _4315_/Y _4323_/S VGND VGND VPWR VPWR _4725_/D sky130_fd_sc_hd__mux2_1
XFILLER_59_216 VGND VGND VPWR VPWR sky130_fd_sc_hd__fill_2
XFILLER_101_335 VGND VGND VPWR VPWR sky130_fd_sc_hd__fill_1
XFILLER_19_15 VPWR VGND VPWR VGND sky130_ef_sc_hd__decap_12
X_4247_ _4254_/C VGND VGND VPWR VPWR _4250_/B sky130_fd_sc_hd__inv_2
XFILLER_59_249 VPWR VGND VPWR VGND sky130_ef_sc_hd__decap_12
X_4178_ _4690_/Q _4176_/C _4691_/Q VGND VGND VPWR VPWR _4178_/X sky130_fd_sc_hd__a21o_1
XFILLER_67_271 VGND VGND VPWR VPWR sky130_fd_sc_hd__decap_8
XTAP_TAPCELL_ROW_2_256 VGND VPWR sky130_fd_sc_hd__tapvpwrvgnd_1
XFILLER_27_113 VPWR VGND VPWR VGND sky130_ef_sc_hd__decap_12
X_3129_ _3826_/A VGND VGND VPWR VPWR _3922_/A sky130_fd_sc_hd__inv_2
XTAP_TAPCELL_ROW_66_962 VGND VPWR sky130_fd_sc_hd__tapvpwrvgnd_1
XTAP_TAPCELL_ROW_38_653 VGND VPWR sky130_fd_sc_hd__tapvpwrvgnd_1
XFILLER_23_330 VGND VGND VPWR VPWR sky130_fd_sc_hd__decap_6
XFILLER_23_341 VGND VGND VPWR VPWR sky130_fd_sc_hd__fill_1
XFILLER_35_69 VPWR VGND VPWR VGND sky130_ef_sc_hd__decap_12
XFILLER_23_374 VPWR VGND VPWR VGND sky130_ef_sc_hd__decap_12
XFILLER_51_57 VPWR VGND VPWR VGND sky130_ef_sc_hd__decap_12
XFILLER_4_3 VPWR VGND VPWR VGND sky130_ef_sc_hd__decap_12
XFILLER_2_245 VGND VGND VPWR VPWR sky130_fd_sc_hd__fill_1
XFILLER_78_525 VGND VGND VPWR VPWR sky130_fd_sc_hd__decap_6
XFILLER_104_195 VGND VGND VPWR VPWR sky130_fd_sc_hd__fill_1
XFILLER_78_569 VPWR VGND VPWR VGND sky130_ef_sc_hd__decap_12
XFILLER_93_517 VPWR VGND VPWR VGND sky130_ef_sc_hd__decap_12
XFILLER_76_65 VGND VGND VPWR VPWR sky130_fd_sc_hd__decap_8
XFILLER_65_208 VGND VGND VPWR VPWR sky130_fd_sc_hd__decap_8
XFILLER_18_135 VGND VGND VPWR VPWR sky130_fd_sc_hd__decap_4
XFILLER_46_477 VGND VGND VPWR VPWR sky130_fd_sc_hd__decap_4
XFILLER_92_53 VPWR VGND VPWR VGND sky130_ef_sc_hd__decap_12
XFILLER_92_97 VGND VGND VPWR VPWR sky130_fd_sc_hd__decap_6
XFILLER_61_447 VGND VGND VPWR VPWR sky130_fd_sc_hd__fill_1
XFILLER_14_385 VGND VGND VPWR VPWR sky130_fd_sc_hd__fill_2
XFILLER_10_580 VGND VGND VPWR VPWR sky130_fd_sc_hd__fill_1
X_2500_ _2498_/Y _2499_/Y _4461_/Q _2526_/B1 VGND VGND VPWR VPWR _4461_/D sky130_fd_sc_hd__a2bb2o_1
X_3480_ _3480_/A _3480_/B VGND VGND VPWR VPWR _3487_/A sky130_fd_sc_hd__xnor2_1
X_2431_ _2431_/A _4769_/Q VGND VGND VPWR VPWR _2431_/Y sky130_fd_sc_hd__nor2_1
XFILLER_37_3 VPWR VGND VPWR VGND sky130_ef_sc_hd__decap_12
X_2362_ hold42/X _2379_/A2 _2379_/B1 _4527_/Q VGND VGND VPWR VPWR _4377_/D sky130_fd_sc_hd__a22o_1
XFILLER_96_333 VPWR VGND VPWR VGND sky130_ef_sc_hd__decap_12
X_2293_ _4688_/Q _2442_/A _2291_/X _2292_/X VGND VGND VPWR VPWR _2293_/X sky130_fd_sc_hd__a22o_1
X_4101_ _4013_/B _4094_/B _4137_/A1 _4094_/Y hold73/X VGND VGND VPWR VPWR _4634_/D
+ sky130_fd_sc_hd__a32o_1
XFILLER_96_377 VPWR VGND VPWR VGND sky130_ef_sc_hd__decap_12
X_4032_ _4113_/A _4068_/B _4131_/B _4068_/D VGND VGND VPWR VPWR _4040_/S sky130_fd_sc_hd__or4_4
XFILLER_49_293 VGND VGND VPWR VPWR sky130_fd_sc_hd__decap_4
XTAP_TAPCELL_ROW_63_921 VGND VPWR sky130_fd_sc_hd__tapvpwrvgnd_1
XFILLER_25_628 VGND VGND VPWR VPWR sky130_fd_sc_hd__fill_1
XTAP_TAPCELL_ROW_35_612 VGND VPWR sky130_fd_sc_hd__tapvpwrvgnd_1
XFILLER_40_609 VGND VGND VPWR VPWR sky130_fd_sc_hd__decap_6
X_3816_ _3817_/A _3817_/B VGND VGND VPWR VPWR _3856_/A sky130_fd_sc_hd__nand2_1
X_3747_ _3839_/A _3839_/B _3794_/B2 VGND VGND VPWR VPWR _3747_/Y sky130_fd_sc_hd__o21ai_1
XFILLER_20_377 VPWR VGND VPWR VGND sky130_ef_sc_hd__decap_12
XFILLER_21_27 VPWR VGND VPWR VGND sky130_ef_sc_hd__decap_12
X_3678_ _3677_/B _3677_/C _3780_/A VGND VGND VPWR VPWR _3732_/B sky130_fd_sc_hd__a21oi_1
XTAP_TAPCELL_ROW_76_1068 VGND VPWR sky130_fd_sc_hd__tapvpwrvgnd_1
X_2629_ _2629_/A _2673_/A VGND VGND VPWR VPWR _2711_/A sky130_fd_sc_hd__or2_1
XTAP_TAPCELL_ROW_7_304 VGND VPWR sky130_fd_sc_hd__tapvpwrvgnd_1
XFILLER_99_193 VPWR VGND VPWR VGND sky130_ef_sc_hd__decap_12
XFILLER_75_517 VPWR VGND VPWR VGND sky130_ef_sc_hd__decap_12
XFILLER_28_400 VPWR VGND VPWR VGND sky130_ef_sc_hd__decap_12
XFILLER_28_433 VGND VGND VPWR VPWR sky130_fd_sc_hd__decap_4
XFILLER_83_561 VPWR VGND VPWR VGND sky130_ef_sc_hd__decap_12
XTAP_TAPCELL_ROW_87_1186 VGND VPWR sky130_fd_sc_hd__tapvpwrvgnd_1
XFILLER_28_477 VPWR VGND VPWR VGND sky130_ef_sc_hd__decap_12
XFILLER_55_263 VGND VGND VPWR VPWR sky130_fd_sc_hd__decap_6
XFILLER_102_41 VPWR VGND VPWR VGND sky130_ef_sc_hd__decap_12
XFILLER_55_296 VPWR VGND VPWR VGND sky130_ef_sc_hd__decap_12
XFILLER_102_85 VPWR VGND VPWR VGND sky130_ef_sc_hd__decap_12
XFILLER_30_119 VGND VGND VPWR VPWR sky130_fd_sc_hd__fill_2
XFILLER_11_322 VGND VGND VPWR VPWR sky130_fd_sc_hd__fill_1
XFILLER_11_344 VGND VGND VPWR VPWR sky130_fd_sc_hd__fill_2
XFILLER_11_377 VPWR VGND VPWR VGND sky130_ef_sc_hd__decap_12
XFILLER_7_337 VGND VGND VPWR VPWR sky130_fd_sc_hd__fill_2
XFILLER_3_532 VGND VGND VPWR VPWR sky130_fd_sc_hd__fill_1
XFILLER_78_344 VGND VGND VPWR VPWR sky130_fd_sc_hd__decap_6
XFILLER_78_377 VPWR VGND VPWR VGND sky130_ef_sc_hd__decap_12
XFILLER_19_400 VPWR VGND VPWR VGND sky130_ef_sc_hd__decap_12
X_2980_ _2981_/B _2981_/C _3027_/A VGND VGND VPWR VPWR _3000_/B sky130_fd_sc_hd__a21o_1
X_4650_ _4684_/CLK _4650_/D fanout139/X VGND VGND VPWR VPWR _4650_/Q sky130_fd_sc_hd__dfrtp_1
XTAP_TAPCELL_ROW_12_361 VGND VPWR sky130_fd_sc_hd__tapvpwrvgnd_1
Xinput10 uio_in[0] VGND VGND VPWR VPWR _2328_/C sky130_fd_sc_hd__buf_1
XTAP_TAPCELL_ROW_40_670 VGND VPWR sky130_fd_sc_hd__tapvpwrvgnd_1
X_3601_ _3601_/A _3601_/B VGND VGND VPWR VPWR _3602_/A sky130_fd_sc_hd__nor2_1
X_4581_ _4679_/CLK _4581_/D fanout138/X VGND VGND VPWR VPWR _4581_/Q sky130_fd_sc_hd__dfrtp_1
X_3532_ _3532_/A _3532_/B _3629_/A VGND VGND VPWR VPWR _3533_/B sky130_fd_sc_hd__and3_1
XFILLER_89_609 VGND VGND VPWR VPWR sky130_fd_sc_hd__decap_6
X_3463_ _3463_/A _3463_/B VGND VGND VPWR VPWR _3465_/B sky130_fd_sc_hd__xnor2_2
X_2414_ _4429_/Q _2414_/A2 _2414_/B1 hold250/X VGND VGND VPWR VPWR _4429_/D sky130_fd_sc_hd__a22o_1
XFILLER_69_333 VGND VGND VPWR VPWR sky130_fd_sc_hd__decap_3
X_3394_ _3394_/A _3394_/B _3394_/C VGND VGND VPWR VPWR _3395_/B sky130_fd_sc_hd__nand3_1
XFILLER_96_141 VPWR VGND VPWR VGND sky130_ef_sc_hd__decap_12
X_2345_ _2347_/C _2345_/B VGND VGND VPWR VPWR _4360_/D sky130_fd_sc_hd__nor2_1
XFILLER_57_517 VPWR VGND VPWR VGND sky130_ef_sc_hd__decap_12
X_2276_ _4708_/Q _2509_/A VGND VGND VPWR VPWR _2276_/X sky130_fd_sc_hd__and2_1
X_4015_ _4131_/D _4068_/B _4113_/C _4556_/D VGND VGND VPWR VPWR _4015_/X sky130_fd_sc_hd__and4_1
XFILLER_65_561 VPWR VGND VPWR VGND sky130_ef_sc_hd__decap_12
XFILLER_80_531 VGND VGND VPWR VPWR sky130_fd_sc_hd__fill_1
XFILLER_16_27 VGND VGND VPWR VPWR sky130_fd_sc_hd__fill_1
XFILLER_33_480 VGND VGND VPWR VPWR sky130_fd_sc_hd__decap_4
XFILLER_32_15 VPWR VGND VPWR VGND sky130_ef_sc_hd__decap_12
XFILLER_0_557 VGND VGND VPWR VPWR sky130_fd_sc_hd__decap_3
XTAP_TAPCELL_ROW_89_1215 VGND VPWR sky130_fd_sc_hd__tapvpwrvgnd_1
XFILLER_57_89 VGND VGND VPWR VPWR sky130_fd_sc_hd__decap_3
XFILLER_90_328 VPWR VGND VPWR VGND sky130_ef_sc_hd__decap_12
XFILLER_73_55 VGND VGND VPWR VPWR sky130_fd_sc_hd__fill_1
XFILLER_43_233 VPWR VGND VPWR VGND sky130_ef_sc_hd__decap_12
XFILLER_73_77 VGND VGND VPWR VPWR sky130_fd_sc_hd__fill_1
XFILLER_71_553 VGND VGND VPWR VPWR sky130_fd_sc_hd__decap_6
XFILLER_16_469 VGND VGND VPWR VPWR sky130_fd_sc_hd__decap_6
XFILLER_71_597 VPWR VGND VPWR VGND sky130_ef_sc_hd__decap_12
XFILLER_12_620 VGND VGND VPWR VPWR sky130_fd_sc_hd__decap_6
XFILLER_8_635 VGND VGND VPWR VPWR sky130_fd_sc_hd__fill_2
XFILLER_98_41 VPWR VGND VPWR VGND sky130_ef_sc_hd__decap_12
XFILLER_98_85 VPWR VGND VPWR VGND sky130_ef_sc_hd__decap_12
XFILLER_94_601 VPWR VGND VPWR VGND sky130_ef_sc_hd__decap_12
XFILLER_93_111 VGND VGND VPWR VPWR sky130_fd_sc_hd__fill_1
XFILLER_39_528 VGND VGND VPWR VPWR sky130_fd_sc_hd__fill_1
XFILLER_93_133 VPWR VGND VPWR VGND sky130_ef_sc_hd__decap_12
XFILLER_19_230 VPWR VGND VPWR VGND sky130_ef_sc_hd__decap_12
XFILLER_47_561 VGND VGND VPWR VPWR sky130_fd_sc_hd__decap_4
XFILLER_62_531 VGND VGND VPWR VPWR sky130_fd_sc_hd__fill_1
XTAP_TAPCELL_ROW_17_420 VGND VPWR sky130_fd_sc_hd__tapvpwrvgnd_1
X_2963_ _2963_/A _2963_/B VGND VGND VPWR VPWR _2963_/X sky130_fd_sc_hd__or2_1
X_4702_ _4724_/CLK _4702_/D fanout159/X VGND VGND VPWR VPWR _4702_/Q sky130_fd_sc_hd__dfrtp_1
X_2894_ _2894_/A _2894_/B VGND VGND VPWR VPWR _2897_/B sky130_fd_sc_hd__xnor2_1
XFILLER_8_83 VGND VGND VPWR VPWR sky130_fd_sc_hd__fill_1
X_4633_ _4667_/CLK _4633_/D fanout125/X VGND VGND VPWR VPWR hold72/A sky130_fd_sc_hd__dfrtp_1
X_4564_ _4661_/CLK _4564_/D fanout123/X VGND VGND VPWR VPWR _4564_/Q sky130_fd_sc_hd__dfrtp_1
X_3515_ _3476_/A _3503_/Y _3479_/B VGND VGND VPWR VPWR _3515_/X sky130_fd_sc_hd__o21a_1
XFILLER_103_205 VPWR VGND VPWR VGND sky130_ef_sc_hd__decap_12
XTAP_TAPCELL_ROW_73_1038 VGND VPWR sky130_fd_sc_hd__tapvpwrvgnd_1
X_4495_ _4495_/CLK _4495_/D fanout129/X VGND VGND VPWR VPWR _4495_/Q sky130_fd_sc_hd__dfrtp_1
XFILLER_103_249 VPWR VGND VPWR VGND sky130_ef_sc_hd__decap_12
X_3446_ _3427_/A _3427_/B _3424_/X VGND VGND VPWR VPWR _3448_/B sky130_fd_sc_hd__a21o_1
XFILLER_97_461 VPWR VGND VPWR VGND sky130_ef_sc_hd__decap_12
X_3377_ _3377_/A VGND VGND VPWR VPWR _3378_/C sky130_fd_sc_hd__inv_2
X_2328_ input13/X _2328_/B _2328_/C VGND VGND VPWR VPWR _4718_/D sky130_fd_sc_hd__and3b_2
XFILLER_27_15 VPWR VGND VPWR VGND sky130_ef_sc_hd__decap_12
X_2259_ _2356_/A _4769_/Q VGND VGND VPWR VPWR _2259_/X sky130_fd_sc_hd__and2_1
XFILLER_72_339 VGND VGND VPWR VPWR sky130_fd_sc_hd__fill_1
XFILLER_25_222 VGND VGND VPWR VPWR sky130_fd_sc_hd__fill_2
XTAP_TAPCELL_ROW_84_1156 VGND VPWR sky130_fd_sc_hd__tapvpwrvgnd_1
XFILLER_80_361 VGND VGND VPWR VPWR sky130_fd_sc_hd__decap_3
XFILLER_43_69 VPWR VGND VPWR VGND sky130_ef_sc_hd__decap_12
XTAP_TAPCELL_ROW_23_489 VGND VPWR sky130_fd_sc_hd__tapvpwrvgnd_1
XTAP_TAPCELL_ROW_51_798 VGND VPWR sky130_fd_sc_hd__tapvpwrvgnd_1
XFILLER_107_533 VPWR VGND VPWR VGND sky130_ef_sc_hd__decap_12
XFILLER_104_3 VPWR VGND VPWR VGND sky130_ef_sc_hd__decap_12
XTAP_TAPCELL_ROW_95_1274 VGND VPWR sky130_fd_sc_hd__tapvpwrvgnd_1
XFILLER_0_321 VPWR VGND VPWR VGND sky130_ef_sc_hd__decap_12
XFILLER_76_601 VPWR VGND VPWR VGND sky130_ef_sc_hd__decap_12
XFILLER_68_77 VGND VGND VPWR VPWR sky130_fd_sc_hd__decap_6
XFILLER_75_111 VGND VGND VPWR VPWR sky130_fd_sc_hd__fill_1
XFILLER_0_365 VGND VGND VPWR VPWR sky130_fd_sc_hd__decap_8
XFILLER_0_376 VGND VGND VPWR VPWR sky130_fd_sc_hd__decap_4
XFILLER_36_509 VGND VGND VPWR VPWR sky130_fd_sc_hd__decap_4
XFILLER_91_615 VGND VGND VPWR VPWR sky130_fd_sc_hd__fill_1
XFILLER_84_65 VGND VGND VPWR VPWR sky130_fd_sc_hd__decap_8
XTAP_TAPCELL_ROW_59_876 VGND VPWR sky130_fd_sc_hd__tapvpwrvgnd_1
XFILLER_44_531 VGND VGND VPWR VPWR sky130_fd_sc_hd__fill_1
XFILLER_90_158 VPWR VGND VPWR VGND sky130_ef_sc_hd__decap_12
XFILLER_71_372 VPWR VGND VPWR VGND sky130_ef_sc_hd__decap_12
XFILLER_44_597 VGND VGND VPWR VPWR sky130_fd_sc_hd__fill_1
XTAP_TAPCELL_ROW_104_1381 VGND VPWR sky130_fd_sc_hd__tapvpwrvgnd_1
X_3300_ _4738_/Q _3300_/B VGND VGND VPWR VPWR _3303_/A sky130_fd_sc_hd__xnor2_1
X_4280_ _4483_/Q _4280_/B VGND VGND VPWR VPWR _4280_/Y sky130_fd_sc_hd__xnor2_1
X_3231_ _4766_/Q _3231_/B VGND VGND VPWR VPWR _3232_/B sky130_fd_sc_hd__or2_1
XFILLER_79_461 VPWR VGND VPWR VGND sky130_ef_sc_hd__decap_12
X_3162_ hold28/A _3162_/B VGND VGND VPWR VPWR _3165_/A sky130_fd_sc_hd__xnor2_1
XFILLER_94_475 VGND VGND VPWR VPWR sky130_fd_sc_hd__fill_1
X_3093_ _3093_/A VGND VGND VPWR VPWR _3094_/B sky130_fd_sc_hd__inv_2
XFILLER_54_306 VGND VGND VPWR VPWR sky130_fd_sc_hd__fill_2
XFILLER_47_391 VGND VGND VPWR VPWR sky130_fd_sc_hd__fill_1
XFILLER_81_169 VGND VGND VPWR VPWR sky130_fd_sc_hd__decap_4
XFILLER_35_553 VGND VGND VPWR VPWR sky130_fd_sc_hd__decap_6
Xfanout29 _4015_/X VGND VGND VPWR VPWR _4094_/B sky130_fd_sc_hd__buf_2
Xfanout18 _4095_/Y VGND VGND VPWR VPWR _4140_/D sky130_fd_sc_hd__clkbuf_4
X_3995_ _3995_/A _3995_/B VGND VGND VPWR VPWR _3995_/X sky130_fd_sc_hd__or2_1
XFILLER_13_39 VPWR VGND VPWR VGND sky130_ef_sc_hd__decap_12
XFILLER_50_589 VGND VGND VPWR VPWR sky130_fd_sc_hd__decap_4
X_2946_ _2973_/A VGND VGND VPWR VPWR _2947_/B sky130_fd_sc_hd__inv_2
XTAP_TAPCELL_ROW_20_448 VGND VPWR sky130_fd_sc_hd__tapvpwrvgnd_1
X_2877_ _2877_/A _2877_/B VGND VGND VPWR VPWR _2879_/A sky130_fd_sc_hd__nand2_2
X_4616_ _4684_/CLK _4616_/D fanout139/X VGND VGND VPWR VPWR hold45/A sky130_fd_sc_hd__dfrtp_1
XFILLER_89_203 VGND VGND VPWR VPWR sky130_fd_sc_hd__decap_8
X_4547_ _4547_/CLK _4547_/D fanout171/X VGND VGND VPWR VPWR _4547_/Q sky130_fd_sc_hd__dfrtp_4
XFILLER_104_525 VGND VGND VPWR VPWR sky130_fd_sc_hd__decap_6
X_4478_ _4538_/CLK _4478_/D fanout172/X VGND VGND VPWR VPWR hold91/A sky130_fd_sc_hd__dfrtp_1
XFILLER_104_569 VPWR VGND VPWR VGND sky130_ef_sc_hd__decap_12
Xstream_cipher_186 VGND VGND VPWR VPWR uio_oe[1] stream_cipher_186/LO sky130_fd_sc_hd__conb_1
Xstream_cipher_175 VGND VGND VPWR VPWR stream_cipher_175/HI uio_oe[3] sky130_fd_sc_hd__conb_1
X_3429_ _3427_/Y _3428_/X _4529_/Q _3470_/B2 VGND VGND VPWR VPWR _4529_/D sky130_fd_sc_hd__a2bb2o_1
XFILLER_58_601 VPWR VGND VPWR VGND sky130_ef_sc_hd__decap_12
XFILLER_73_615 VGND VGND VPWR VPWR sky130_fd_sc_hd__fill_1
XFILLER_18_509 VGND VGND VPWR VPWR sky130_fd_sc_hd__fill_1
XFILLER_57_155 VPWR VGND VPWR VGND sky130_ef_sc_hd__decap_12
XFILLER_85_497 VGND VGND VPWR VPWR sky130_fd_sc_hd__decap_6
XFILLER_72_136 VGND VGND VPWR VPWR sky130_fd_sc_hd__decap_4
XTAP_TAPCELL_ROW_28_537 VGND VPWR sky130_fd_sc_hd__tapvpwrvgnd_1
XTAP_TAPCELL_ROW_56_846 VGND VPWR sky130_fd_sc_hd__tapvpwrvgnd_1
XFILLER_80_191 VGND VGND VPWR VPWR sky130_fd_sc_hd__decap_4
XFILLER_9_207 VGND VGND VPWR VPWR sky130_fd_sc_hd__decap_8
XTAP_TAPCELL_ROW_97_1303 VGND VPWR sky130_fd_sc_hd__tapvpwrvgnd_1
XFILLER_68_409 VGND VGND VPWR VPWR sky130_fd_sc_hd__fill_1
XFILLER_95_217 VGND VGND VPWR VPWR sky130_fd_sc_hd__decap_6
XFILLER_36_306 VGND VGND VPWR VPWR sky130_fd_sc_hd__fill_2
XFILLER_29_391 VGND VGND VPWR VPWR sky130_fd_sc_hd__fill_1
XFILLER_63_169 VGND VGND VPWR VPWR sky130_fd_sc_hd__decap_8
X_3780_ _3780_/A _3987_/A VGND VGND VPWR VPWR _3782_/B sky130_fd_sc_hd__xor2_1
X_2800_ _2782_/A _2782_/B _2782_/C _2778_/A VGND VGND VPWR VPWR _2801_/B sky130_fd_sc_hd__a31o_1
XFILLER_32_589 VGND VGND VPWR VPWR sky130_fd_sc_hd__fill_1
X_2731_ _4498_/Q _2732_/B VGND VGND VPWR VPWR _2758_/A sky130_fd_sc_hd__and2_1
XFILLER_12_291 VGND VGND VPWR VPWR sky130_fd_sc_hd__decap_3
XFILLER_8_251 VGND VGND VPWR VPWR sky130_fd_sc_hd__fill_1
X_4401_ _4542_/CLK _4401_/D fanout168/X VGND VGND VPWR VPWR _4401_/Q sky130_fd_sc_hd__dfrtp_1
XFILLER_67_3 VPWR VGND VPWR VGND sky130_ef_sc_hd__decap_12
X_2662_ _2662_/A _2662_/B VGND VGND VPWR VPWR _2663_/B sky130_fd_sc_hd__xnor2_1
X_2593_ _4738_/Q _2593_/B VGND VGND VPWR VPWR _2594_/B sky130_fd_sc_hd__or2_1
XFILLER_5_51 VGND VGND VPWR VPWR sky130_fd_sc_hd__decap_4
X_4332_ _2325_/C _3434_/A _4339_/A2 _4744_/Q VGND VGND VPWR VPWR _4744_/D sky130_fd_sc_hd__a2bb2o_1
X_4263_ _4714_/Q _4265_/B _4259_/B _4715_/Q VGND VGND VPWR VPWR _4264_/B sky130_fd_sc_hd__a31o_1
XFILLER_101_517 VPWR VGND VPWR VGND sky130_ef_sc_hd__decap_12
XFILLER_86_239 VPWR VGND VPWR VGND sky130_ef_sc_hd__decap_12
XFILLER_86_228 VGND VGND VPWR VPWR sky130_fd_sc_hd__fill_1
XFILLER_86_217 VGND VGND VPWR VPWR sky130_fd_sc_hd__decap_3
X_3214_ _3212_/Y _3214_/B VGND VGND VPWR VPWR _3215_/B sky130_fd_sc_hd__and2b_1
X_4194_ _4696_/Q _4695_/Q _4194_/C VGND VGND VPWR VPWR _4197_/B sky130_fd_sc_hd__and3_1
X_3145_ _3145_/A _3145_/B VGND VGND VPWR VPWR _3146_/B sky130_fd_sc_hd__xnor2_1
XFILLER_55_615 VGND VGND VPWR VPWR sky130_fd_sc_hd__fill_1
XFILLER_82_445 VPWR VGND VPWR VGND sky130_ef_sc_hd__decap_12
X_3076_ _3054_/A _3051_/Y _3052_/Y VGND VGND VPWR VPWR _3076_/Y sky130_fd_sc_hd__a21oi_1
XFILLER_54_158 VGND VGND VPWR VPWR sky130_fd_sc_hd__fill_2
XFILLER_82_489 VPWR VGND VPWR VGND sky130_ef_sc_hd__decap_12
XFILLER_23_501 VGND VGND VPWR VPWR sky130_fd_sc_hd__decap_3
XTAP_TAPCELL_ROW_25_507 VGND VPWR sky130_fd_sc_hd__tapvpwrvgnd_1
XTAP_TAPCELL_ROW_53_816 VGND VPWR sky130_fd_sc_hd__tapvpwrvgnd_1
XTAP_TAPCELL_ROW_81_1126 VGND VPWR sky130_fd_sc_hd__tapvpwrvgnd_1
XFILLER_24_27 VGND VGND VPWR VPWR sky130_fd_sc_hd__fill_1
X_3978_ _3978_/A _3978_/B VGND VGND VPWR VPWR _3978_/Y sky130_fd_sc_hd__nand2_1
XFILLER_50_353 VGND VGND VPWR VPWR sky130_fd_sc_hd__decap_8
XFILLER_10_217 VGND VGND VPWR VPWR sky130_fd_sc_hd__decap_8
XTAP_TAPCELL_ROW_33_595 VGND VPWR sky130_fd_sc_hd__tapvpwrvgnd_1
X_2929_ _2933_/A VGND VGND VPWR VPWR _3028_/A sky130_fd_sc_hd__inv_2
XFILLER_40_15 VPWR VGND VPWR VGND sky130_ef_sc_hd__decap_12
XTAP_TAPCELL_ROW_79_1099 VGND VPWR sky130_fd_sc_hd__tapvpwrvgnd_1
XTAP_TAPCELL_ROW_92_1244 VGND VPWR sky130_fd_sc_hd__tapvpwrvgnd_1
Xhold240 _4445_/Q VGND VGND VPWR VPWR hold240/X sky130_fd_sc_hd__dlygate4sd3_1
Xhold251 _4500_/Q VGND VGND VPWR VPWR hold251/X sky130_fd_sc_hd__dlygate4sd3_1
Xhold262 _4503_/Q VGND VGND VPWR VPWR hold262/X sky130_fd_sc_hd__dlygate4sd3_1
XFILLER_104_333 VPWR VGND VPWR VGND sky130_ef_sc_hd__decap_12
Xhold273 _4687_/Q VGND VGND VPWR VPWR hold273/X sky130_fd_sc_hd__dlygate4sd3_1
Xhold284 _4456_/Q VGND VGND VPWR VPWR hold284/X sky130_fd_sc_hd__dlygate4sd3_1
Xhold295 _4506_/Q VGND VGND VPWR VPWR hold295/X sky130_fd_sc_hd__dlygate4sd3_1
XFILLER_104_377 VPWR VGND VPWR VGND sky130_ef_sc_hd__decap_12
XFILLER_77_228 VPWR VGND VPWR VGND sky130_ef_sc_hd__decap_12
XFILLER_49_57 VGND VGND VPWR VPWR sky130_fd_sc_hd__decap_8
XFILLER_58_431 VPWR VGND VPWR VGND sky130_ef_sc_hd__decap_12
XFILLER_92_209 VGND VGND VPWR VPWR sky130_fd_sc_hd__decap_3
XTAP_TAPCELL_ROW_5_287 VGND VPWR sky130_fd_sc_hd__tapvpwrvgnd_1
XFILLER_58_475 VGND VGND VPWR VPWR sky130_fd_sc_hd__fill_1
XTAP_TAPCELL_ROW_69_993 VGND VPWR sky130_fd_sc_hd__tapvpwrvgnd_1
XFILLER_45_169 VGND VGND VPWR VPWR sky130_fd_sc_hd__decap_6
XFILLER_61_629 VGND VGND VPWR VPWR sky130_fd_sc_hd__decap_8
XFILLER_26_394 VGND VGND VPWR VPWR sky130_fd_sc_hd__decap_8
XTAP_TAPCELL_ROW_101_1340 VGND VPWR sky130_fd_sc_hd__tapvpwrvgnd_1
XFILLER_81_55 VGND VGND VPWR VPWR sky130_fd_sc_hd__fill_1
XFILLER_5_210 VGND VGND VPWR VPWR sky130_fd_sc_hd__fill_2
XFILLER_107_193 VGND VGND VPWR VPWR sky130_fd_sc_hd__decap_3
XFILLER_83_209 VPWR VGND VPWR VGND sky130_ef_sc_hd__decap_12
Xinput8 ui_in[6] VGND VGND VPWR VPWR input8/X sky130_fd_sc_hd__clkbuf_1
XFILLER_37_615 VGND VGND VPWR VPWR sky130_fd_sc_hd__fill_1
XFILLER_64_467 VGND VGND VPWR VPWR sky130_fd_sc_hd__decap_8
XFILLER_36_147 VPWR VGND VPWR VGND sky130_ef_sc_hd__decap_12
XFILLER_91_275 VGND VGND VPWR VPWR sky130_fd_sc_hd__decap_4
XFILLER_64_489 VPWR VGND VPWR VGND sky130_ef_sc_hd__decap_12
X_3901_ _3902_/A _3987_/A VGND VGND VPWR VPWR _3903_/A sky130_fd_sc_hd__nor2_1
X_3832_ _3785_/X _3828_/X _3830_/X _3829_/X _3833_/A VGND VGND VPWR VPWR _3862_/B
+ sky130_fd_sc_hd__a311o_1
X_3763_ _3763_/A _3763_/B VGND VGND VPWR VPWR _3765_/B sky130_fd_sc_hd__xnor2_1
X_3694_ _3794_/B2 _3692_/X _3693_/Y _3748_/B2 _4540_/Q VGND VGND VPWR VPWR _4540_/D
+ sky130_fd_sc_hd__a32o_1
XFILLER_9_593 VGND VGND VPWR VPWR sky130_fd_sc_hd__fill_1
XFILLER_9_582 VGND VGND VPWR VPWR sky130_fd_sc_hd__decap_4
X_2714_ _2653_/B _2674_/A _2711_/C _2713_/Y _2693_/Y VGND VGND VPWR VPWR _2720_/B
+ sky130_fd_sc_hd__o311a_1
XTAP_TAPCELL_ROW_30_565 VGND VPWR sky130_fd_sc_hd__tapvpwrvgnd_1
X_2645_ _3438_/A VGND VGND VPWR VPWR _3351_/A sky130_fd_sc_hd__inv_2
XFILLER_10_29 VPWR VGND VPWR VGND sky130_ef_sc_hd__decap_12
X_2576_ _4490_/Q _2576_/B VGND VGND VPWR VPWR _2577_/B sky130_fd_sc_hd__or2_1
X_4315_ _4488_/Q _4315_/B VGND VGND VPWR VPWR _4315_/Y sky130_fd_sc_hd__xnor2_1
XFILLER_87_559 VGND VGND VPWR VPWR sky130_fd_sc_hd__fill_1
XFILLER_19_27 VPWR VGND VPWR VGND sky130_ef_sc_hd__decap_12
X_4246_ _4711_/Q _4710_/Q _4246_/C VGND VGND VPWR VPWR _4254_/C sky130_fd_sc_hd__and3_1
X_4177_ _4183_/C VGND VGND VPWR VPWR _4177_/Y sky130_fd_sc_hd__inv_2
XFILLER_28_604 VGND VGND VPWR VPWR sky130_fd_sc_hd__decap_8
XFILLER_55_401 VPWR VGND VPWR VGND sky130_ef_sc_hd__decap_12
X_3128_ _3128_/A _3128_/B VGND VGND VPWR VPWR _3826_/A sky130_fd_sc_hd__xnor2_4
XFILLER_27_125 VGND VGND VPWR VPWR sky130_fd_sc_hd__fill_1
XFILLER_28_626 VGND VGND VPWR VPWR sky130_fd_sc_hd__decap_4
XFILLER_55_434 VGND VGND VPWR VPWR sky130_fd_sc_hd__fill_2
XFILLER_82_253 VGND VGND VPWR VPWR sky130_fd_sc_hd__fill_1
XFILLER_82_242 VGND VGND VPWR VPWR sky130_fd_sc_hd__decap_8
XTAP_TAPCELL_ROW_66_963 VGND VPWR sky130_fd_sc_hd__tapvpwrvgnd_1
XTAP_TAPCELL_ROW_2_257 VGND VPWR sky130_fd_sc_hd__tapvpwrvgnd_1
XFILLER_35_15 VPWR VGND VPWR VGND sky130_ef_sc_hd__decap_12
XTAP_TAPCELL_ROW_38_654 VGND VPWR sky130_fd_sc_hd__tapvpwrvgnd_1
X_3059_ _4758_/Q _3059_/B VGND VGND VPWR VPWR _3060_/B sky130_fd_sc_hd__or2_1
XFILLER_23_386 VGND VGND VPWR VPWR sky130_fd_sc_hd__decap_6
XFILLER_50_183 VPWR VGND VPWR VGND sky130_ef_sc_hd__decap_12
XFILLER_7_519 VGND VGND VPWR VPWR sky130_fd_sc_hd__decap_8
XFILLER_51_69 VGND VGND VPWR VPWR sky130_fd_sc_hd__fill_2
XFILLER_104_141 VPWR VGND VPWR VGND sky130_ef_sc_hd__decap_12
XFILLER_93_529 VPWR VGND VPWR VGND sky130_ef_sc_hd__decap_12
XFILLER_58_250 VGND VGND VPWR VPWR sky130_fd_sc_hd__fill_2
XFILLER_86_581 VGND VGND VPWR VPWR sky130_fd_sc_hd__decap_6
XFILLER_76_99 VGND VGND VPWR VPWR sky130_fd_sc_hd__decap_3
XFILLER_46_401 VGND VGND VPWR VPWR sky130_fd_sc_hd__fill_1
XFILLER_46_434 VPWR VGND VPWR VGND sky130_ef_sc_hd__decap_12
XFILLER_18_147 VPWR VGND VPWR VGND sky130_ef_sc_hd__decap_12
XFILLER_92_65 VPWR VGND VPWR VGND sky130_ef_sc_hd__decap_12
XFILLER_25_81 VGND VGND VPWR VPWR sky130_fd_sc_hd__decap_8
XFILLER_14_397 VPWR VGND VPWR VGND sky130_ef_sc_hd__decap_12
X_2430_ _2258_/B _2429_/X _2422_/B _2250_/A VGND VGND VPWR VPWR _4439_/D sky130_fd_sc_hd__a2bb2o_1
XFILLER_96_301 VGND VGND VPWR VPWR sky130_fd_sc_hd__decap_6
X_2361_ hold33/X _2379_/A2 _2379_/B1 _4526_/Q VGND VGND VPWR VPWR _4376_/D sky130_fd_sc_hd__a22o_1
XFILLER_96_345 VPWR VGND VPWR VGND sky130_ef_sc_hd__decap_12
XFILLER_69_559 VGND VGND VPWR VPWR sky130_fd_sc_hd__fill_1
X_2292_ _4687_/Q _2438_/A VGND VGND VPWR VPWR _2292_/X sky130_fd_sc_hd__or2_1
X_4100_ _4013_/B _4094_/B _4136_/A1 _4094_/Y hold72/X VGND VGND VPWR VPWR _4633_/D
+ sky130_fd_sc_hd__a32o_1
XFILLER_96_389 VPWR VGND VPWR VGND sky130_ef_sc_hd__decap_12
XFILLER_2_41 VPWR VGND VPWR VGND sky130_ef_sc_hd__decap_12
X_4031_ _4095_/B _4094_/B _4139_/A1 _4016_/Y hold47/X VGND VGND VPWR VPWR _4572_/D
+ sky130_fd_sc_hd__a32o_1
XFILLER_2_85 VPWR VGND VPWR VGND sky130_ef_sc_hd__decap_12
XFILLER_64_253 VGND VGND VPWR VPWR sky130_fd_sc_hd__decap_8
XTAP_TAPCELL_ROW_63_922 VGND VPWR sky130_fd_sc_hd__tapvpwrvgnd_1
XTAP_TAPCELL_ROW_35_613 VGND VPWR sky130_fd_sc_hd__tapvpwrvgnd_1
XFILLER_64_297 VGND VGND VPWR VPWR sky130_fd_sc_hd__decap_8
XFILLER_24_139 VGND VGND VPWR VPWR sky130_fd_sc_hd__fill_1
X_3815_ _4645_/Q _4581_/Q hold83/A hold48/A _3915_/S0 _3915_/S1 VGND VGND VPWR VPWR
+ _3817_/B sky130_fd_sc_hd__mux4_1
XTAP_TAPCELL_ROW_15_392 VGND VPWR sky130_fd_sc_hd__tapvpwrvgnd_1
X_3746_ _3839_/A _3839_/B VGND VGND VPWR VPWR _3769_/B sky130_fd_sc_hd__and2_1
XFILLER_20_389 VPWR VGND VPWR VGND sky130_ef_sc_hd__decap_12
XFILLER_21_39 VPWR VGND VPWR VGND sky130_ef_sc_hd__decap_12
X_3677_ _3780_/A _3677_/B _3677_/C VGND VGND VPWR VPWR _3735_/A sky130_fd_sc_hd__and3_1
XTAP_TAPCELL_ROW_76_1069 VGND VPWR sky130_fd_sc_hd__tapvpwrvgnd_1
X_2628_ _4740_/Q _2628_/B VGND VGND VPWR VPWR _2673_/A sky130_fd_sc_hd__and2_1
XTAP_TAPCELL_ROW_7_305 VGND VPWR sky130_fd_sc_hd__tapvpwrvgnd_1
XFILLER_102_601 VPWR VGND VPWR VGND sky130_ef_sc_hd__decap_12
XFILLER_99_161 VGND VGND VPWR VPWR sky130_fd_sc_hd__decap_6
X_2559_ hold187/X _4728_/Q _2566_/S VGND VGND VPWR VPWR _4482_/D sky130_fd_sc_hd__mux2_1
XFILLER_101_111 VGND VGND VPWR VPWR sky130_fd_sc_hd__fill_1
X_4229_ _4706_/Q _4229_/B VGND VGND VPWR VPWR _4235_/C sky130_fd_sc_hd__and2_1
XFILLER_75_529 VPWR VGND VPWR VGND sky130_ef_sc_hd__decap_12
XFILLER_68_581 VGND VGND VPWR VPWR sky130_fd_sc_hd__decap_6
XFILLER_28_412 VGND VGND VPWR VPWR sky130_fd_sc_hd__fill_2
XFILLER_55_220 VGND VGND VPWR VPWR sky130_fd_sc_hd__decap_4
XFILLER_83_573 VPWR VGND VPWR VGND sky130_ef_sc_hd__decap_12
XFILLER_28_489 VGND VGND VPWR VPWR sky130_fd_sc_hd__decap_3
XFILLER_102_53 VPWR VGND VPWR VGND sky130_ef_sc_hd__decap_12
XTAP_TAPCELL_ROW_87_1187 VGND VPWR sky130_fd_sc_hd__tapvpwrvgnd_1
XFILLER_102_97 VPWR VGND VPWR VGND sky130_ef_sc_hd__decap_12
XFILLER_11_334 VGND VGND VPWR VPWR sky130_fd_sc_hd__fill_2
XPHY_EDGE_ROW_12_Left_120 VGND VGND VPWR VPWR sky130_fd_sc_hd__decap_3
XFILLER_11_389 VGND VGND VPWR VPWR sky130_fd_sc_hd__decap_3
XFILLER_3_500 VGND VGND VPWR VPWR sky130_fd_sc_hd__decap_4
XFILLER_3_511 VGND VGND VPWR VPWR sky130_fd_sc_hd__fill_1
XFILLER_11_94 VGND VGND VPWR VPWR sky130_fd_sc_hd__decap_6
XFILLER_105_461 VPWR VGND VPWR VGND sky130_ef_sc_hd__decap_12
XFILLER_93_337 VPWR VGND VPWR VGND sky130_ef_sc_hd__decap_12
XFILLER_93_326 VGND VGND VPWR VPWR sky130_fd_sc_hd__decap_8
XFILLER_78_389 VGND VGND VPWR VPWR sky130_fd_sc_hd__decap_4
XFILLER_19_412 VGND VGND VPWR VPWR sky130_fd_sc_hd__decap_6
XFILLER_46_253 VGND VGND VPWR VPWR sky130_fd_sc_hd__decap_6
XFILLER_14_150 VGND VGND VPWR VPWR sky130_fd_sc_hd__decap_6
X_4580_ _4679_/CLK _4580_/D fanout138/X VGND VGND VPWR VPWR _4580_/Q sky130_fd_sc_hd__dfrtp_1
XTAP_TAPCELL_ROW_12_362 VGND VPWR sky130_fd_sc_hd__tapvpwrvgnd_1
Xinput11 uio_in[3] VGND VGND VPWR VPWR _3995_/B sky130_fd_sc_hd__clkbuf_1
XTAP_TAPCELL_ROW_40_671 VGND VPWR sky130_fd_sc_hd__tapvpwrvgnd_1
X_3600_ _3601_/A _3601_/B VGND VGND VPWR VPWR _3603_/A sky130_fd_sc_hd__nand2_1
X_3531_ _3532_/A _3532_/B _3629_/A VGND VGND VPWR VPWR _3533_/A sky130_fd_sc_hd__a21oi_1
X_3462_ _3462_/A _3462_/B VGND VGND VPWR VPWR _3463_/B sky130_fd_sc_hd__xnor2_1
X_2413_ _4428_/Q _2420_/A2 _2420_/B1 hold226/X VGND VGND VPWR VPWR _4428_/D sky130_fd_sc_hd__a22o_1
X_3393_ _3394_/A _3394_/B _3394_/C VGND VGND VPWR VPWR _3415_/B sky130_fd_sc_hd__a21o_1
X_2344_ _4131_/D _4556_/D VGND VGND VPWR VPWR _2345_/B sky130_fd_sc_hd__nor2_1
XFILLER_96_153 VPWR VGND VPWR VGND sky130_ef_sc_hd__decap_12
XFILLER_69_345 VGND VGND VPWR VPWR sky130_fd_sc_hd__decap_8
XFILLER_96_197 VPWR VGND VPWR VGND sky130_ef_sc_hd__decap_12
XFILLER_84_326 VGND VGND VPWR VPWR sky130_fd_sc_hd__fill_1
X_2275_ _2265_/A _2273_/Y _2319_/C VGND VGND VPWR VPWR _2275_/Y sky130_fd_sc_hd__a21oi_1
XFILLER_57_529 VPWR VGND VPWR VGND sky130_ef_sc_hd__decap_12
XFILLER_84_359 VGND VGND VPWR VPWR sky130_fd_sc_hd__decap_4
XFILLER_37_220 VGND VGND VPWR VPWR sky130_fd_sc_hd__decap_4
X_4014_ _4556_/D _4095_/B VGND VGND VPWR VPWR _4068_/D sky130_fd_sc_hd__nand2_1
XFILLER_65_573 VPWR VGND VPWR VGND sky130_ef_sc_hd__decap_12
XTAP_TAPCELL_ROW_48_760 VGND VPWR sky130_fd_sc_hd__tapvpwrvgnd_1
XFILLER_80_587 VGND VGND VPWR VPWR sky130_fd_sc_hd__fill_1
XFILLER_21_610 VGND VGND VPWR VPWR sky130_fd_sc_hd__decap_6
XFILLER_21_621 VPWR VGND VPWR VGND sky130_ef_sc_hd__decap_12
XFILLER_32_27 VGND VGND VPWR VPWR sky130_fd_sc_hd__fill_1
X_3729_ _3730_/A _3730_/B _3730_/C _3730_/D VGND VGND VPWR VPWR _3776_/B sky130_fd_sc_hd__a31o_1
XFILLER_0_503 VGND VGND VPWR VPWR sky130_fd_sc_hd__fill_1
XFILLER_102_475 VGND VGND VPWR VPWR sky130_fd_sc_hd__fill_1
XTAP_TAPCELL_ROW_89_1216 VGND VPWR sky130_fd_sc_hd__tapvpwrvgnd_1
XFILLER_87_175 VGND VGND VPWR VPWR sky130_fd_sc_hd__fill_1
XFILLER_75_337 VPWR VGND VPWR VGND sky130_ef_sc_hd__decap_12
XFILLER_57_57 VPWR VGND VPWR VGND sky130_ef_sc_hd__decap_12
XFILLER_87_197 VPWR VGND VPWR VGND sky130_ef_sc_hd__decap_12
XFILLER_28_220 VGND VGND VPWR VPWR sky130_fd_sc_hd__decap_8
XFILLER_90_307 VGND VGND VPWR VPWR sky130_fd_sc_hd__fill_1
XFILLER_28_253 VGND VGND VPWR VPWR sky130_fd_sc_hd__decap_8
XFILLER_43_201 VGND VGND VPWR VPWR sky130_fd_sc_hd__decap_8
XFILLER_43_223 VGND VGND VPWR VPWR sky130_fd_sc_hd__fill_1
XFILLER_31_407 VGND VGND VPWR VPWR sky130_fd_sc_hd__fill_1
XFILLER_43_245 VPWR VGND VPWR VGND sky130_ef_sc_hd__decap_12
XFILLER_12_632 VGND VGND VPWR VPWR sky130_fd_sc_hd__fill_2
XFILLER_7_124 VGND VGND VPWR VPWR sky130_fd_sc_hd__decap_4
XFILLER_98_53 VPWR VGND VPWR VGND sky130_ef_sc_hd__decap_12
XFILLER_98_97 VPWR VGND VPWR VGND sky130_ef_sc_hd__decap_12
XFILLER_94_613 VPWR VGND VPWR VGND sky130_ef_sc_hd__decap_12
XFILLER_93_145 VGND VGND VPWR VPWR sky130_fd_sc_hd__fill_1
XFILLER_78_197 VGND VGND VPWR VPWR sky130_fd_sc_hd__fill_2
XFILLER_19_242 VPWR VGND VPWR VGND sky130_ef_sc_hd__decap_12
XFILLER_74_381 VPWR VGND VPWR VGND sky130_ef_sc_hd__decap_12
XTAP_TAPCELL_ROW_17_421 VGND VPWR sky130_fd_sc_hd__tapvpwrvgnd_1
XFILLER_34_212 VGND VGND VPWR VPWR sky130_fd_sc_hd__decap_4
XFILLER_34_234 VGND VGND VPWR VPWR sky130_fd_sc_hd__decap_4
XTAP_TAPCELL_ROW_45_730 VGND VPWR sky130_fd_sc_hd__tapvpwrvgnd_1
XFILLER_22_407 VPWR VGND VPWR VGND sky130_ef_sc_hd__decap_12
XFILLER_34_267 VPWR VGND VPWR VGND sky130_ef_sc_hd__decap_12
XFILLER_97_3 VPWR VGND VPWR VGND sky130_ef_sc_hd__decap_12
XFILLER_62_587 VGND VGND VPWR VPWR sky130_fd_sc_hd__fill_1
XFILLER_22_429 VGND VGND VPWR VPWR sky130_fd_sc_hd__fill_1
X_2962_ _3008_/A _2962_/B VGND VGND VPWR VPWR _3009_/A sky130_fd_sc_hd__or2_1
X_4701_ _4724_/CLK _4701_/D fanout157/X VGND VGND VPWR VPWR _4701_/Q sky130_fd_sc_hd__dfrtp_2
XFILLER_30_473 VGND VGND VPWR VPWR sky130_fd_sc_hd__decap_3
X_4632_ _4667_/CLK _4632_/D fanout124/X VGND VGND VPWR VPWR hold64/A sky130_fd_sc_hd__dfrtp_1
X_2893_ _2893_/A _2916_/B VGND VGND VPWR VPWR _2894_/B sky130_fd_sc_hd__xor2_1
X_4563_ _4661_/CLK _4563_/D fanout123/X VGND VGND VPWR VPWR _4563_/Q sky130_fd_sc_hd__dfrtp_1
X_4494_ _4499_/CLK _4494_/D fanout129/X VGND VGND VPWR VPWR _4494_/Q sky130_fd_sc_hd__dfrtp_2
X_3514_ _3512_/Y _3513_/X _4533_/Q _2558_/B VGND VGND VPWR VPWR _4533_/D sky130_fd_sc_hd__a2bb2o_1
XTAP_TAPCELL_ROW_73_1039 VGND VPWR sky130_fd_sc_hd__tapvpwrvgnd_1
X_3445_ _4530_/Q _3445_/B VGND VGND VPWR VPWR _3448_/A sky130_fd_sc_hd__xor2_1
XFILLER_103_217 VGND VGND VPWR VPWR sky130_fd_sc_hd__decap_6
X_3376_ _3376_/A _3376_/B VGND VGND VPWR VPWR _3377_/A sky130_fd_sc_hd__xor2_1
XFILLER_97_473 VPWR VGND VPWR VGND sky130_ef_sc_hd__decap_12
X_2327_ _2354_/A hold279/X _2431_/A VGND VGND VPWR VPWR _4768_/D sky130_fd_sc_hd__a21o_1
XFILLER_57_315 VGND VGND VPWR VPWR sky130_fd_sc_hd__decap_4
XFILLER_27_27 VPWR VGND VPWR VGND sky130_ef_sc_hd__decap_12
X_2258_ _2258_/A _2258_/B VGND VGND VPWR VPWR _4368_/D sky130_fd_sc_hd__nand2_1
XFILLER_72_307 VGND VGND VPWR VPWR sky130_fd_sc_hd__fill_1
XFILLER_65_370 VGND VGND VPWR VPWR sky130_fd_sc_hd__fill_1
X_2189_ _4699_/Q VGND VGND VPWR VPWR _4204_/A sky130_fd_sc_hd__inv_2
XFILLER_38_595 VGND VGND VPWR VPWR sky130_fd_sc_hd__decap_3
XTAP_TAPCELL_ROW_84_1157 VGND VPWR sky130_fd_sc_hd__tapvpwrvgnd_1
XFILLER_13_418 VPWR VGND VPWR VGND sky130_ef_sc_hd__decap_12
XFILLER_43_15 VPWR VGND VPWR VGND sky130_ef_sc_hd__decap_12
XTAP_TAPCELL_ROW_51_788 VGND VPWR sky130_fd_sc_hd__tapvpwrvgnd_1
XFILLER_107_501 VGND VGND VPWR VPWR sky130_fd_sc_hd__decap_3
XFILLER_5_617 VPWR VGND VPWR VGND sky130_ef_sc_hd__decap_12
XFILLER_107_545 VPWR VGND VPWR VGND sky130_ef_sc_hd__decap_12
XFILLER_107_589 VPWR VGND VPWR VGND sky130_ef_sc_hd__decap_12
XTAP_TAPCELL_ROW_95_1275 VGND VPWR sky130_fd_sc_hd__tapvpwrvgnd_1
XFILLER_0_333 VGND VGND VPWR VPWR sky130_fd_sc_hd__decap_3
XFILLER_76_613 VPWR VGND VPWR VGND sky130_ef_sc_hd__decap_12
XFILLER_75_178 VGND VGND VPWR VPWR sky130_fd_sc_hd__fill_1
XTAP_TAPCELL_ROW_59_877 VGND VPWR sky130_fd_sc_hd__tapvpwrvgnd_1
XFILLER_16_234 VGND VGND VPWR VPWR sky130_fd_sc_hd__fill_1
XFILLER_71_384 VGND VGND VPWR VPWR sky130_fd_sc_hd__decap_8
XFILLER_44_587 VGND VGND VPWR VPWR sky130_fd_sc_hd__fill_1
XTAP_TAPCELL_ROW_104_1371 VGND VPWR sky130_fd_sc_hd__tapvpwrvgnd_1
XFILLER_8_444 VGND VGND VPWR VPWR sky130_fd_sc_hd__decap_4
XFILLER_8_477 VPWR VGND VPWR VGND sky130_ef_sc_hd__decap_12
X_3230_ _4766_/Q _3231_/B VGND VGND VPWR VPWR _3230_/X sky130_fd_sc_hd__and2_1
XFILLER_100_209 VPWR VGND VPWR VGND sky130_ef_sc_hd__decap_12
XFILLER_79_473 VPWR VGND VPWR VGND sky130_ef_sc_hd__decap_12
X_3161_ _3791_/A hold4/A VGND VGND VPWR VPWR _3162_/B sky130_fd_sc_hd__xor2_1
XFILLER_94_421 VPWR VGND VPWR VGND sky130_ef_sc_hd__decap_12
XFILLER_12_3 VPWR VGND VPWR VGND sky130_ef_sc_hd__decap_12
X_3092_ _4545_/Q _3092_/B _3092_/C VGND VGND VPWR VPWR _3093_/A sky130_fd_sc_hd__nand3_1
XFILLER_81_137 VGND VGND VPWR VPWR sky130_fd_sc_hd__fill_1
XFILLER_47_381 VGND VGND VPWR VPWR sky130_fd_sc_hd__fill_1
XFILLER_54_329 VGND VGND VPWR VPWR sky130_fd_sc_hd__fill_1
XFILLER_81_159 VGND VGND VPWR VPWR sky130_fd_sc_hd__decap_8
Xfanout19 _3522_/B VGND VGND VPWR VPWR _3519_/S sky130_fd_sc_hd__clkbuf_4
X_3994_ _2328_/C _2328_/B _3993_/Y hold154/X VGND VGND VPWR VPWR _4554_/D sky130_fd_sc_hd__a22o_1
X_2945_ _2944_/B _2944_/C _4539_/Q VGND VGND VPWR VPWR _2973_/A sky130_fd_sc_hd__a21oi_2
X_2876_ _4504_/Q _2876_/B VGND VGND VPWR VPWR _2877_/B sky130_fd_sc_hd__or2_1
X_4615_ _4679_/CLK _4615_/D fanout138/X VGND VGND VPWR VPWR hold38/A sky130_fd_sc_hd__dfrtp_1
XTAP_TAPCELL_ROW_20_449 VGND VPWR sky130_fd_sc_hd__tapvpwrvgnd_1
X_4546_ _4547_/CLK _4546_/D fanout170/X VGND VGND VPWR VPWR hold14/A sky130_fd_sc_hd__dfrtp_1
X_4477_ _4715_/CLK _4477_/D fanout172/X VGND VGND VPWR VPWR _4477_/Q sky130_fd_sc_hd__dfrtp_1
Xstream_cipher_187 VGND VGND VPWR VPWR uio_oe[2] stream_cipher_187/LO sky130_fd_sc_hd__conb_1
Xstream_cipher_176 VGND VGND VPWR VPWR stream_cipher_176/HI uio_oe[4] sky130_fd_sc_hd__conb_1
X_3428_ _3427_/A _3427_/B _3468_/A VGND VGND VPWR VPWR _3428_/X sky130_fd_sc_hd__a21o_1
X_3359_ _3337_/A _3337_/B _3333_/X VGND VGND VPWR VPWR _3359_/X sky130_fd_sc_hd__a21o_1
XFILLER_38_15 VPWR VGND VPWR VGND sky130_ef_sc_hd__decap_12
XFILLER_58_613 VPWR VGND VPWR VGND sky130_ef_sc_hd__decap_12
XFILLER_97_281 VPWR VGND VPWR VGND sky130_ef_sc_hd__decap_12
XFILLER_85_432 VPWR VGND VPWR VGND sky130_ef_sc_hd__decap_12
XFILLER_57_167 VGND VGND VPWR VPWR sky130_fd_sc_hd__fill_1
XFILLER_72_115 VGND VGND VPWR VPWR sky130_fd_sc_hd__fill_1
XTAP_TAPCELL_ROW_28_538 VGND VPWR sky130_fd_sc_hd__tapvpwrvgnd_1
XTAP_TAPCELL_ROW_56_847 VGND VPWR sky130_fd_sc_hd__tapvpwrvgnd_1
XFILLER_26_598 VGND VGND VPWR VPWR sky130_fd_sc_hd__fill_1
XFILLER_41_502 VGND VGND VPWR VPWR sky130_fd_sc_hd__fill_2
XTAP_TAPCELL_ROW_97_1304 VGND VPWR sky130_fd_sc_hd__tapvpwrvgnd_1
XFILLER_21_281 VGND VGND VPWR VPWR sky130_fd_sc_hd__decap_8
XFILLER_5_436 VGND VGND VPWR VPWR sky130_fd_sc_hd__decap_3
XFILLER_79_55 VGND VGND VPWR VPWR sky130_fd_sc_hd__fill_1
XFILLER_79_99 VGND VGND VPWR VPWR sky130_fd_sc_hd__fill_1
XFILLER_0_141 VPWR VGND VPWR VGND sky130_ef_sc_hd__decap_12
XTAP_TAPCELL_ROW_106_1400 VGND VPWR sky130_fd_sc_hd__tapvpwrvgnd_1
XFILLER_63_126 VGND VGND VPWR VPWR sky130_fd_sc_hd__fill_1
XFILLER_17_532 VGND VGND VPWR VPWR sky130_fd_sc_hd__decap_8
XFILLER_71_192 VGND VGND VPWR VPWR sky130_fd_sc_hd__fill_1
XPHY_EDGE_ROW_4_Left_112 VGND VGND VPWR VPWR sky130_fd_sc_hd__decap_3
XFILLER_44_91 VGND VGND VPWR VPWR sky130_fd_sc_hd__fill_1
X_2730_ _2730_/A _2730_/B VGND VGND VPWR VPWR _2732_/B sky130_fd_sc_hd__xnor2_1
X_2661_ _2711_/B _2661_/B VGND VGND VPWR VPWR _2662_/B sky130_fd_sc_hd__xor2_1
X_4400_ _4542_/CLK _4400_/D fanout167/X VGND VGND VPWR VPWR _4400_/Q sky130_fd_sc_hd__dfrtp_1
X_2592_ _4738_/Q _2593_/B VGND VGND VPWR VPWR _2592_/X sky130_fd_sc_hd__and2_1
X_4331_ _4743_/Q _4331_/A2 _3412_/A _4331_/B2 VGND VGND VPWR VPWR _4743_/D sky130_fd_sc_hd__a22o_1
XFILLER_4_480 VPWR VGND VPWR VGND sky130_ef_sc_hd__decap_12
X_4262_ _4262_/A _4262_/B VGND VGND VPWR VPWR _4264_/A sky130_fd_sc_hd__or2_1
XFILLER_101_529 VPWR VGND VPWR VGND sky130_ef_sc_hd__decap_12
X_3213_ _4547_/Q _4551_/Q VGND VGND VPWR VPWR _3214_/B sky130_fd_sc_hd__nand2_1
XFILLER_79_281 VPWR VGND VPWR VGND sky130_ef_sc_hd__decap_12
X_4193_ _4695_/Q _4694_/Q _4187_/B _4696_/Q VGND VGND VPWR VPWR _4193_/X sky130_fd_sc_hd__a31o_1
XFILLER_94_251 VGND VGND VPWR VPWR sky130_fd_sc_hd__fill_1
X_3144_ _3144_/A _3144_/B VGND VGND VPWR VPWR _3145_/B sky130_fd_sc_hd__nor2_1
X_3075_ _3105_/A VGND VGND VPWR VPWR _3106_/B sky130_fd_sc_hd__inv_2
XFILLER_82_457 VPWR VGND VPWR VGND sky130_ef_sc_hd__decap_12
XTAP_TAPCELL_ROW_25_508 VGND VPWR sky130_fd_sc_hd__tapvpwrvgnd_1
XTAP_TAPCELL_ROW_53_817 VGND VPWR sky130_fd_sc_hd__tapvpwrvgnd_1
XTAP_TAPCELL_ROW_81_1127 VGND VPWR sky130_fd_sc_hd__tapvpwrvgnd_1
XFILLER_62_192 VGND VGND VPWR VPWR sky130_fd_sc_hd__decap_4
XFILLER_23_557 VGND VGND VPWR VPWR sky130_fd_sc_hd__decap_3
XFILLER_50_321 VGND VGND VPWR VPWR sky130_fd_sc_hd__decap_4
XPHY_EDGE_ROW_59_Left_167 VGND VGND VPWR VPWR sky130_fd_sc_hd__decap_3
X_3977_ _4551_/Q _3953_/B _3974_/X _3956_/B _3976_/A VGND VGND VPWR VPWR _3978_/B
+ sky130_fd_sc_hd__o221ai_4
XFILLER_50_365 VGND VGND VPWR VPWR sky130_fd_sc_hd__fill_2
XTAP_TAPCELL_ROW_33_596 VGND VPWR sky130_fd_sc_hd__tapvpwrvgnd_1
X_2928_ _2928_/A _2928_/B VGND VGND VPWR VPWR _2933_/A sky130_fd_sc_hd__nor2_2
XFILLER_40_27 VGND VGND VPWR VPWR sky130_fd_sc_hd__fill_1
X_2859_ hold77/A _4603_/Q hold67/A _4667_/Q _2746_/S _2747_/A VGND VGND VPWR VPWR
+ _2861_/B sky130_fd_sc_hd__mux4_1
XFILLER_104_301 VGND VGND VPWR VPWR sky130_fd_sc_hd__decap_6
XTAP_TAPCELL_ROW_92_1245 VGND VPWR sky130_fd_sc_hd__tapvpwrvgnd_1
XPHY_EDGE_ROW_68_Left_176 VGND VGND VPWR VPWR sky130_fd_sc_hd__decap_3
XFILLER_2_417 VGND VGND VPWR VPWR sky130_fd_sc_hd__decap_3
X_4529_ _4531_/CLK _4529_/D fanout150/X VGND VGND VPWR VPWR _4529_/Q sky130_fd_sc_hd__dfrtp_4
Xhold230 _4700_/Q VGND VGND VPWR VPWR hold230/X sky130_fd_sc_hd__dlygate4sd3_1
Xhold241 _4502_/Q VGND VGND VPWR VPWR hold241/X sky130_fd_sc_hd__dlygate4sd3_1
Xhold252 _4709_/Q VGND VGND VPWR VPWR hold252/X sky130_fd_sc_hd__dlygate4sd3_1
XFILLER_104_345 VPWR VGND VPWR VGND sky130_ef_sc_hd__decap_12
Xhold274 _4689_/Q VGND VGND VPWR VPWR hold274/X sky130_fd_sc_hd__dlygate4sd3_1
Xhold285 _4455_/Q VGND VGND VPWR VPWR hold285/X sky130_fd_sc_hd__dlygate4sd3_1
Xhold263 _4688_/Q VGND VGND VPWR VPWR hold263/X sky130_fd_sc_hd__dlygate4sd3_1
Xhold296 _4746_/Q VGND VGND VPWR VPWR hold296/X sky130_fd_sc_hd__dlygate4sd3_1
XFILLER_104_389 VPWR VGND VPWR VGND sky130_ef_sc_hd__decap_12
XFILLER_58_421 VGND VGND VPWR VPWR sky130_fd_sc_hd__decap_3
XFILLER_58_443 VGND VGND VPWR VPWR sky130_fd_sc_hd__decap_4
XTAP_TAPCELL_ROW_5_288 VGND VPWR sky130_fd_sc_hd__tapvpwrvgnd_1
XFILLER_73_424 VGND VGND VPWR VPWR sky130_fd_sc_hd__fill_2
XTAP_TAPCELL_ROW_69_994 VGND VPWR sky130_fd_sc_hd__tapvpwrvgnd_1
XFILLER_65_57 VGND VGND VPWR VPWR sky130_fd_sc_hd__decap_8
XPHY_EDGE_ROW_77_Left_185 VGND VGND VPWR VPWR sky130_fd_sc_hd__decap_3
XFILLER_26_373 VGND VGND VPWR VPWR sky130_fd_sc_hd__fill_1
XTAP_TAPCELL_ROW_101_1341 VGND VPWR sky130_fd_sc_hd__tapvpwrvgnd_1
XFILLER_41_398 VGND VGND VPWR VPWR sky130_fd_sc_hd__decap_4
XFILLER_14_83 VGND VGND VPWR VPWR sky130_fd_sc_hd__fill_1
XPHY_EDGE_ROW_86_Left_194 VGND VGND VPWR VPWR sky130_fd_sc_hd__decap_3
XFILLER_49_432 VGND VGND VPWR VPWR sky130_fd_sc_hd__fill_1
XFILLER_64_413 VGND VGND VPWR VPWR sky130_fd_sc_hd__decap_6
Xinput9 ui_in[7] VGND VGND VPWR VPWR input9/X sky130_fd_sc_hd__clkbuf_1
XFILLER_37_627 VGND VGND VPWR VPWR sky130_fd_sc_hd__decap_8
XFILLER_36_159 VPWR VGND VPWR VGND sky130_ef_sc_hd__decap_12
XFILLER_17_373 VGND VGND VPWR VPWR sky130_fd_sc_hd__fill_2
X_3900_ _3900_/A _3900_/B VGND VGND VPWR VPWR _3906_/A sky130_fd_sc_hd__xnor2_2
X_3831_ _3785_/X _3828_/X _3830_/X _3829_/X VGND VGND VPWR VPWR _3833_/B sky130_fd_sc_hd__a31o_1
X_3762_ _3762_/A _3762_/B VGND VGND VPWR VPWR _3763_/B sky130_fd_sc_hd__xnor2_1
XFILLER_9_550 VGND VGND VPWR VPWR sky130_fd_sc_hd__decap_3
X_3693_ _3693_/A _3693_/B VGND VGND VPWR VPWR _3693_/Y sky130_fd_sc_hd__nand2_1
X_2713_ _4743_/Q _2694_/B _2670_/Y VGND VGND VPWR VPWR _2713_/Y sky130_fd_sc_hd__o21bai_1
XTAP_TAPCELL_ROW_30_566 VGND VPWR sky130_fd_sc_hd__tapvpwrvgnd_1
X_2644_ _2644_/A _2644_/B VGND VGND VPWR VPWR _3438_/A sky130_fd_sc_hd__xor2_2
X_2575_ _4490_/Q _2576_/B VGND VGND VPWR VPWR _2588_/A sky130_fd_sc_hd__nand2_1
X_4314_ _4318_/A _4313_/Y _4311_/Y _2250_/A VGND VGND VPWR VPWR _4315_/B sky130_fd_sc_hd__a211o_1
XFILLER_87_505 VPWR VGND VPWR VGND sky130_ef_sc_hd__decap_12
XFILLER_101_337 VPWR VGND VPWR VGND sky130_ef_sc_hd__decap_12
X_4245_ _4265_/B _4243_/X _4244_/Y _4262_/A hold266/X VGND VGND VPWR VPWR _4710_/D
+ sky130_fd_sc_hd__a32o_1
X_4176_ _4691_/Q _4690_/Q _4176_/C VGND VGND VPWR VPWR _4183_/C sky130_fd_sc_hd__and3_1
XFILLER_19_39 VPWR VGND VPWR VGND sky130_ef_sc_hd__decap_12
X_3127_ _3127_/A _3127_/B VGND VGND VPWR VPWR _3128_/B sky130_fd_sc_hd__and2_2
XFILLER_55_413 VGND VGND VPWR VPWR sky130_fd_sc_hd__decap_6
XTAP_TAPCELL_ROW_66_953 VGND VPWR sky130_fd_sc_hd__tapvpwrvgnd_1
XTAP_TAPCELL_ROW_2_258 VGND VPWR sky130_fd_sc_hd__tapvpwrvgnd_1
XTAP_TAPCELL_ROW_38_655 VGND VPWR sky130_fd_sc_hd__tapvpwrvgnd_1
X_3058_ _4758_/Q _3059_/B VGND VGND VPWR VPWR _3060_/A sky130_fd_sc_hd__nand2_1
XFILLER_35_27 VPWR VGND VPWR VGND sky130_ef_sc_hd__decap_12
XFILLER_23_398 VPWR VGND VPWR VGND sky130_ef_sc_hd__decap_12
XFILLER_51_15 VPWR VGND VPWR VGND sky130_ef_sc_hd__decap_12
XFILLER_50_195 VGND VGND VPWR VPWR sky130_fd_sc_hd__fill_1
XFILLER_2_225 VPWR VGND VPWR VGND sky130_ef_sc_hd__decap_12
XFILLER_104_153 VPWR VGND VPWR VGND sky130_ef_sc_hd__decap_12
XFILLER_104_197 VPWR VGND VPWR VGND sky130_ef_sc_hd__decap_12
XFILLER_58_273 VGND VGND VPWR VPWR sky130_fd_sc_hd__decap_6
XFILLER_18_159 VGND VGND VPWR VPWR sky130_fd_sc_hd__fill_1
XFILLER_46_446 VGND VGND VPWR VPWR sky130_fd_sc_hd__fill_2
XFILLER_73_287 VPWR VGND VPWR VGND sky130_ef_sc_hd__decap_12
XFILLER_33_107 VGND VGND VPWR VPWR sky130_fd_sc_hd__decap_4
XFILLER_92_77 VGND VGND VPWR VPWR sky130_fd_sc_hd__decap_6
XFILLER_61_449 VGND VGND VPWR VPWR sky130_fd_sc_hd__decap_3
XFILLER_14_321 VGND VGND VPWR VPWR sky130_fd_sc_hd__decap_4
Xclkbuf_leaf_53_clk clkload1/A VGND VGND VPWR VPWR _4739_/CLK sky130_fd_sc_hd__clkbuf_8
XFILLER_14_365 VPWR VGND VPWR VGND sky130_ef_sc_hd__decap_12
XFILLER_41_162 VGND VGND VPWR VPWR sky130_fd_sc_hd__fill_2
XPHY_EDGE_ROW_94_Left_202 VGND VGND VPWR VPWR sky130_fd_sc_hd__decap_3
XFILLER_10_571 VGND VGND VPWR VPWR sky130_fd_sc_hd__fill_1
XFILLER_6_531 VGND VGND VPWR VPWR sky130_fd_sc_hd__fill_1
XFILLER_69_505 VPWR VGND VPWR VGND sky130_ef_sc_hd__decap_12
X_2360_ hold53/X _2408_/A2 _2375_/B1 _4525_/Q VGND VGND VPWR VPWR _4375_/D sky130_fd_sc_hd__a22o_1
X_2291_ _4686_/Q _2182_/Y _4687_/Q _2438_/A _2290_/X VGND VGND VPWR VPWR _2291_/X
+ sky130_fd_sc_hd__a221o_1
XFILLER_96_357 VGND VGND VPWR VPWR sky130_fd_sc_hd__decap_6
XPHY_EDGE_ROW_10_Right_10 VGND VGND VPWR VPWR sky130_fd_sc_hd__decap_3
XFILLER_2_53 VPWR VGND VPWR VGND sky130_ef_sc_hd__decap_12
X_4030_ _4735_/Q _4030_/B VGND VGND VPWR VPWR _4030_/X sky130_fd_sc_hd__and2_2
XFILLER_64_210 VPWR VGND VPWR VGND sky130_ef_sc_hd__decap_12
XFILLER_64_232 VPWR VGND VPWR VGND sky130_ef_sc_hd__decap_12
XFILLER_2_97 VPWR VGND VPWR VGND sky130_ef_sc_hd__decap_12
XFILLER_37_457 VGND VGND VPWR VPWR sky130_fd_sc_hd__decap_4
XTAP_TAPCELL_ROW_63_923 VGND VPWR sky130_fd_sc_hd__tapvpwrvgnd_1
XFILLER_25_608 VGND VGND VPWR VPWR sky130_fd_sc_hd__decap_8
XTAP_TAPCELL_ROW_35_614 VGND VPWR sky130_fd_sc_hd__tapvpwrvgnd_1
Xclkbuf_leaf_44_clk clkload4/A VGND VGND VPWR VPWR _4734_/CLK sky130_fd_sc_hd__clkbuf_8
XFILLER_17_181 VPWR VGND VPWR VGND sky130_ef_sc_hd__decap_12
XFILLER_32_162 VGND VGND VPWR VPWR sky130_fd_sc_hd__decap_8
X_3814_ _3814_/A _3849_/B VGND VGND VPWR VPWR _3817_/A sky130_fd_sc_hd__xnor2_1
XTAP_TAPCELL_ROW_15_393 VGND VPWR sky130_fd_sc_hd__tapvpwrvgnd_1
XFILLER_32_195 VGND VGND VPWR VPWR sky130_fd_sc_hd__fill_1
X_3745_ _3769_/A _3745_/B VGND VGND VPWR VPWR _3839_/B sky130_fd_sc_hd__nor2_1
XFILLER_9_391 VGND VGND VPWR VPWR sky130_fd_sc_hd__fill_1
X_3676_ _3676_/A _3676_/B _3676_/C VGND VGND VPWR VPWR _3677_/C sky130_fd_sc_hd__nand3_1
X_2627_ _4740_/Q _2628_/B VGND VGND VPWR VPWR _2629_/A sky130_fd_sc_hd__nor2_1
XFILLER_102_613 VPWR VGND VPWR VGND sky130_ef_sc_hd__decap_12
XTAP_TAPCELL_ROW_7_306 VGND VPWR sky130_fd_sc_hd__tapvpwrvgnd_1
X_2558_ _4481_/Q _2558_/B VGND VGND VPWR VPWR _4481_/D sky130_fd_sc_hd__and2_1
X_2489_ _2492_/B VGND VGND VPWR VPWR _2489_/Y sky130_fd_sc_hd__inv_2
X_4228_ _4706_/Q _4229_/B VGND VGND VPWR VPWR _4228_/X sky130_fd_sc_hd__or2_1
XFILLER_101_167 VGND VGND VPWR VPWR sky130_fd_sc_hd__fill_1
XFILLER_46_15 VPWR VGND VPWR VGND sky130_ef_sc_hd__decap_12
XPHY_EDGE_ROW_106_Right_106 VGND VGND VPWR VPWR sky130_fd_sc_hd__decap_3
XFILLER_83_541 VPWR VGND VPWR VGND sky130_ef_sc_hd__decap_12
X_4159_ _4685_/Q _4686_/Q VGND VGND VPWR VPWR _4159_/X sky130_fd_sc_hd__or2_1
XFILLER_83_585 VPWR VGND VPWR VGND sky130_ef_sc_hd__decap_12
XFILLER_43_405 VGND VGND VPWR VPWR sky130_fd_sc_hd__fill_1
XFILLER_55_276 VGND VGND VPWR VPWR sky130_fd_sc_hd__decap_4
XTAP_TAPCELL_ROW_87_1188 VGND VPWR sky130_fd_sc_hd__tapvpwrvgnd_1
XFILLER_102_65 VPWR VGND VPWR VGND sky130_ef_sc_hd__decap_12
Xclkbuf_leaf_35_clk _4459_/CLK VGND VGND VPWR VPWR _4708_/CLK sky130_fd_sc_hd__clkbuf_8
XFILLER_11_51 VGND VGND VPWR VPWR sky130_fd_sc_hd__decap_4
XFILLER_105_473 VPWR VGND VPWR VGND sky130_ef_sc_hd__decap_12
XFILLER_87_55 VGND VGND VPWR VPWR sky130_fd_sc_hd__fill_1
XFILLER_78_357 VGND VGND VPWR VPWR sky130_fd_sc_hd__decap_6
XFILLER_93_349 VPWR VGND VPWR VGND sky130_ef_sc_hd__decap_12
XFILLER_61_268 VGND VGND VPWR VPWR sky130_fd_sc_hd__fill_2
XFILLER_61_279 VGND VGND VPWR VPWR sky130_fd_sc_hd__fill_1
XFILLER_14_195 VGND VGND VPWR VPWR sky130_fd_sc_hd__fill_1
XTAP_TAPCELL_ROW_12_363 VGND VPWR sky130_fd_sc_hd__tapvpwrvgnd_1
Xinput12 uio_in[4] VGND VGND VPWR VPWR _2340_/A sky130_fd_sc_hd__buf_1
XTAP_TAPCELL_ROW_40_672 VGND VPWR sky130_fd_sc_hd__tapvpwrvgnd_1
X_3530_ _3633_/A _3530_/B VGND VGND VPWR VPWR _3629_/A sky130_fd_sc_hd__xnor2_1
XFILLER_6_361 VGND VGND VPWR VPWR sky130_fd_sc_hd__decap_3
X_3461_ _3461_/A _3461_/B VGND VGND VPWR VPWR _3462_/B sky130_fd_sc_hd__xor2_1
X_3392_ _3415_/A _3392_/B VGND VGND VPWR VPWR _3394_/C sky130_fd_sc_hd__nand2_1
XFILLER_42_3 VPWR VGND VPWR VGND sky130_ef_sc_hd__decap_12
X_2412_ hold181/X _2420_/A2 _2420_/B1 _4513_/Q VGND VGND VPWR VPWR _4427_/D sky130_fd_sc_hd__a22o_1
XFILLER_96_121 VPWR VGND VPWR VGND sky130_ef_sc_hd__decap_12
X_2343_ _4041_/A _4095_/A VGND VGND VPWR VPWR _2347_/C sky130_fd_sc_hd__nor2_1
XFILLER_96_165 VPWR VGND VPWR VGND sky130_ef_sc_hd__decap_12
X_2274_ _4715_/Q _2200_/Y _4714_/Q _2529_/A VGND VGND VPWR VPWR _2319_/C sky130_fd_sc_hd__a22o_1
X_4013_ _4095_/A _4013_/B VGND VGND VPWR VPWR _4013_/Y sky130_fd_sc_hd__nor2_4
XFILLER_65_541 VPWR VGND VPWR VGND sky130_ef_sc_hd__decap_12
XFILLER_37_232 VPWR VGND VPWR VGND sky130_ef_sc_hd__decap_12
XTAP_TAPCELL_ROW_48_761 VGND VPWR sky130_fd_sc_hd__tapvpwrvgnd_1
XFILLER_92_393 VPWR VGND VPWR VGND sky130_ef_sc_hd__decap_12
XFILLER_80_533 VPWR VGND VPWR VGND sky130_ef_sc_hd__decap_12
XFILLER_65_585 VPWR VGND VPWR VGND sky130_ef_sc_hd__decap_12
XFILLER_16_29 VPWR VGND VPWR VGND sky130_ef_sc_hd__decap_12
XFILLER_25_438 VGND VGND VPWR VPWR sky130_fd_sc_hd__decap_3
Xclkbuf_leaf_17_clk clkload3/A VGND VGND VPWR VPWR _4767_/CLK sky130_fd_sc_hd__clkbuf_8
XFILLER_52_268 VGND VGND VPWR VPWR sky130_fd_sc_hd__fill_1
XFILLER_40_419 VGND VGND VPWR VPWR sky130_fd_sc_hd__fill_1
XFILLER_21_633 VGND VGND VPWR VPWR sky130_fd_sc_hd__decap_4
X_3728_ _3776_/A _3728_/B VGND VGND VPWR VPWR _3730_/D sky130_fd_sc_hd__nand2_1
XFILLER_4_309 VGND VGND VPWR VPWR sky130_fd_sc_hd__fill_2
X_3659_ _3659_/A _3659_/B VGND VGND VPWR VPWR _3660_/B sky130_fd_sc_hd__xnor2_1
XFILLER_102_421 VPWR VGND VPWR VGND sky130_ef_sc_hd__decap_12
XFILLER_87_110 VGND VGND VPWR VPWR sky130_fd_sc_hd__fill_2
XTAP_TAPCELL_ROW_89_1206 VGND VPWR sky130_fd_sc_hd__tapvpwrvgnd_1
XFILLER_57_69 VPWR VGND VPWR VGND sky130_ef_sc_hd__decap_12
XFILLER_75_349 VGND VGND VPWR VPWR sky130_fd_sc_hd__fill_1
XFILLER_83_393 VPWR VGND VPWR VGND sky130_ef_sc_hd__decap_12
XFILLER_16_427 VGND VGND VPWR VPWR sky130_fd_sc_hd__decap_6
XFILLER_73_57 VPWR VGND VPWR VGND sky130_ef_sc_hd__decap_12
XFILLER_43_257 VGND VGND VPWR VPWR sky130_fd_sc_hd__decap_3
XFILLER_11_121 VGND VGND VPWR VPWR sky130_fd_sc_hd__fill_1
XFILLER_24_493 VGND VGND VPWR VPWR sky130_fd_sc_hd__fill_1
XFILLER_22_83 VGND VGND VPWR VPWR sky130_fd_sc_hd__fill_1
XFILLER_98_419 VGND VGND VPWR VPWR sky130_fd_sc_hd__fill_1
XFILLER_98_65 VPWR VGND VPWR VGND sky130_ef_sc_hd__decap_12
XFILLER_3_375 VPWR VGND VPWR VGND sky130_ef_sc_hd__decap_12
XFILLER_105_281 VPWR VGND VPWR VGND sky130_ef_sc_hd__decap_12
XFILLER_94_625 VPWR VGND VPWR VGND sky130_ef_sc_hd__decap_12
XFILLER_66_305 VGND VGND VPWR VPWR sky130_fd_sc_hd__decap_3
XFILLER_81_319 VGND VGND VPWR VPWR sky130_fd_sc_hd__decap_4
XFILLER_19_254 VGND VGND VPWR VPWR sky130_fd_sc_hd__decap_4
XFILLER_47_574 VGND VGND VPWR VPWR sky130_fd_sc_hd__fill_1
XFILLER_74_393 VGND VGND VPWR VPWR sky130_fd_sc_hd__decap_8
XFILLER_62_533 VPWR VGND VPWR VGND sky130_ef_sc_hd__decap_12
XTAP_TAPCELL_ROW_17_422 VGND VPWR sky130_fd_sc_hd__tapvpwrvgnd_1
XTAP_TAPCELL_ROW_45_731 VGND VPWR sky130_fd_sc_hd__tapvpwrvgnd_1
XFILLER_22_419 VGND VGND VPWR VPWR sky130_fd_sc_hd__fill_1
XFILLER_34_279 VPWR VGND VPWR VGND sky130_ef_sc_hd__decap_12
X_2961_ _4754_/Q _2961_/B VGND VGND VPWR VPWR _2962_/B sky130_fd_sc_hd__nor2_1
X_4700_ _4724_/CLK _4700_/D fanout166/X VGND VGND VPWR VPWR _4700_/Q sky130_fd_sc_hd__dfrtp_1
XFILLER_8_41 VPWR VGND VPWR VGND sky130_ef_sc_hd__decap_12
X_4631_ _4667_/CLK _4631_/D fanout126/X VGND VGND VPWR VPWR hold71/A sky130_fd_sc_hd__dfrtp_1
X_2892_ _2892_/A _2892_/B VGND VGND VPWR VPWR _2894_/A sky130_fd_sc_hd__xnor2_1
XFILLER_8_85 VPWR VGND VPWR VGND sky130_ef_sc_hd__decap_12
X_4562_ _4656_/CLK _4562_/D fanout120/X VGND VGND VPWR VPWR _4562_/Q sky130_fd_sc_hd__dfrtp_1
X_4493_ _4527_/CLK _4493_/D fanout129/X VGND VGND VPWR VPWR _4493_/Q sky130_fd_sc_hd__dfrtp_1
X_3513_ _3488_/Y _3492_/Y _3511_/Y _3468_/A VGND VGND VPWR VPWR _3513_/X sky130_fd_sc_hd__a31o_1
X_3444_ _4530_/Q _3445_/B VGND VGND VPWR VPWR _3467_/A sky130_fd_sc_hd__nand2_1
XPHY_EDGE_ROW_31_Left_139 VGND VGND VPWR VPWR sky130_fd_sc_hd__decap_3
Xclkbuf_leaf_6_clk clkload1/A VGND VGND VPWR VPWR _4509_/CLK sky130_fd_sc_hd__clkbuf_8
XFILLER_97_441 VGND VGND VPWR VPWR sky130_fd_sc_hd__decap_6
X_3375_ _3374_/A _3374_/B _3376_/A VGND VGND VPWR VPWR _3394_/B sky130_fd_sc_hd__a21bo_1
XFILLER_97_485 VPWR VGND VPWR VGND sky130_ef_sc_hd__decap_12
X_2326_ _4768_/Q _2254_/Y _2324_/Y _2432_/A VGND VGND VPWR VPWR _4769_/D sky130_fd_sc_hd__a211o_1
XFILLER_57_305 VGND VGND VPWR VPWR sky130_fd_sc_hd__decap_3
X_2257_ _2431_/A _2257_/B _4365_/Q VGND VGND VPWR VPWR _2258_/B sky130_fd_sc_hd__or3b_1
XFILLER_27_39 VPWR VGND VPWR VGND sky130_ef_sc_hd__decap_12
XFILLER_38_563 VPWR VGND VPWR VGND sky130_ef_sc_hd__decap_12
XFILLER_65_393 VGND VGND VPWR VPWR sky130_fd_sc_hd__decap_4
X_2188_ _4445_/Q VGND VGND VPWR VPWR _2188_/Y sky130_fd_sc_hd__inv_2
XFILLER_53_533 VPWR VGND VPWR VGND sky130_ef_sc_hd__decap_12
XTAP_TAPCELL_ROW_84_1158 VGND VPWR sky130_fd_sc_hd__tapvpwrvgnd_1
XPHY_EDGE_ROW_40_Left_148 VGND VGND VPWR VPWR sky130_fd_sc_hd__decap_3
XFILLER_43_27 VPWR VGND VPWR VGND sky130_ef_sc_hd__decap_12
XFILLER_40_238 VPWR VGND VPWR VGND sky130_ef_sc_hd__decap_12
XTAP_TAPCELL_ROW_51_789 VGND VPWR sky130_fd_sc_hd__tapvpwrvgnd_1
XFILLER_5_629 VGND VGND VPWR VPWR sky130_fd_sc_hd__decap_8
XFILLER_107_557 VGND VGND VPWR VPWR sky130_fd_sc_hd__decap_3
XTAP_TAPCELL_ROW_95_1276 VGND VPWR sky130_fd_sc_hd__tapvpwrvgnd_1
XFILLER_102_251 VGND VGND VPWR VPWR sky130_fd_sc_hd__fill_1
XFILLER_76_625 VPWR VGND VPWR VGND sky130_ef_sc_hd__decap_12
XFILLER_48_305 VGND VGND VPWR VPWR sky130_fd_sc_hd__decap_3
XFILLER_91_617 VPWR VGND VPWR VGND sky130_ef_sc_hd__decap_12
XTAP_TAPCELL_ROW_59_878 VGND VPWR sky130_fd_sc_hd__tapvpwrvgnd_1
XFILLER_29_585 VGND VGND VPWR VPWR sky130_fd_sc_hd__fill_1
XFILLER_44_533 VGND VGND VPWR VPWR sky130_fd_sc_hd__fill_2
XTAP_TAPCELL_ROW_104_1372 VGND VPWR sky130_fd_sc_hd__tapvpwrvgnd_1
XFILLER_8_489 VPWR VGND VPWR VGND sky130_ef_sc_hd__decap_12
XFILLER_79_485 VPWR VGND VPWR VGND sky130_ef_sc_hd__decap_12
X_3160_ _3179_/B _3160_/B VGND VGND VPWR VPWR _3166_/A sky130_fd_sc_hd__nand2_1
XFILLER_94_433 VPWR VGND VPWR VGND sky130_ef_sc_hd__decap_12
X_3091_ _3092_/B _3092_/C _4545_/Q VGND VGND VPWR VPWR _3122_/A sky130_fd_sc_hd__a21oi_1
Xhold1 hold1/A VGND VGND VPWR VPWR hold1/X sky130_fd_sc_hd__dlygate4sd3_1
XFILLER_94_477 VPWR VGND VPWR VGND sky130_ef_sc_hd__decap_12
XFILLER_47_371 VGND VGND VPWR VPWR sky130_fd_sc_hd__decap_3
XFILLER_62_363 VGND VGND VPWR VPWR sky130_fd_sc_hd__fill_1
XPHY_EDGE_ROW_8_Right_8 VGND VGND VPWR VPWR sky130_fd_sc_hd__decap_3
XFILLER_35_577 VGND VGND VPWR VPWR sky130_fd_sc_hd__fill_1
X_3993_ _4555_/Q _4786_/A VGND VGND VPWR VPWR _3993_/Y sky130_fd_sc_hd__nand2b_1
XFILLER_22_238 VPWR VGND VPWR VGND sky130_ef_sc_hd__decap_12
X_2944_ _4539_/Q _2944_/B _2944_/C VGND VGND VPWR VPWR _2947_/A sky130_fd_sc_hd__nand3_1
X_2875_ _4504_/Q _2876_/B VGND VGND VPWR VPWR _2877_/A sky130_fd_sc_hd__nand2_1
X_4614_ _4758_/CLK _4614_/D fanout140/X VGND VGND VPWR VPWR hold46/A sky130_fd_sc_hd__dfrtp_1
X_4545_ _4547_/CLK _4545_/D fanout170/X VGND VGND VPWR VPWR _4545_/Q sky130_fd_sc_hd__dfrtp_4
X_4476_ _4538_/CLK _4476_/D fanout172/X VGND VGND VPWR VPWR hold89/A sky130_fd_sc_hd__dfrtp_1
Xstream_cipher_177 VGND VGND VPWR VPWR stream_cipher_177/HI uio_oe[5] sky130_fd_sc_hd__conb_1
X_3427_ _3427_/A _3427_/B VGND VGND VPWR VPWR _3427_/Y sky130_fd_sc_hd__nor2_1
XPHY_EDGE_ROW_39_Right_39 VGND VGND VPWR VPWR sky130_fd_sc_hd__decap_3
X_3358_ _3357_/B _3357_/C _4526_/Q VGND VGND VPWR VPWR _3358_/X sky130_fd_sc_hd__a21o_1
XFILLER_38_27 VGND VGND VPWR VPWR sky130_fd_sc_hd__fill_1
XFILLER_58_625 VPWR VGND VPWR VGND sky130_ef_sc_hd__decap_12
XFILLER_97_293 VPWR VGND VPWR VGND sky130_ef_sc_hd__decap_12
XFILLER_85_444 VGND VGND VPWR VPWR sky130_fd_sc_hd__decap_4
X_2309_ _4697_/Q _2471_/A _4696_/Q _2193_/Y _2311_/B VGND VGND VPWR VPWR _2310_/B
+ sky130_fd_sc_hd__o221a_1
XFILLER_57_113 VPWR VGND VPWR VGND sky130_ef_sc_hd__decap_12
XFILLER_73_617 VPWR VGND VPWR VGND sky130_ef_sc_hd__decap_12
X_3289_ _3278_/A _3270_/B _3304_/A _3287_/X VGND VGND VPWR VPWR _3290_/B sky130_fd_sc_hd__a2bb2o_1
XTAP_TAPCELL_ROW_28_539 VGND VPWR sky130_fd_sc_hd__tapvpwrvgnd_1
XTAP_TAPCELL_ROW_56_848 VGND VPWR sky130_fd_sc_hd__tapvpwrvgnd_1
XFILLER_26_533 VGND VGND VPWR VPWR sky130_fd_sc_hd__fill_2
XFILLER_53_341 VPWR VGND VPWR VGND sky130_ef_sc_hd__decap_12
XFILLER_54_15 VPWR VGND VPWR VGND sky130_ef_sc_hd__decap_12
XFILLER_13_205 VGND VGND VPWR VPWR sky130_fd_sc_hd__fill_2
XPHY_EDGE_ROW_48_Right_48 VGND VGND VPWR VPWR sky130_fd_sc_hd__decap_3
XFILLER_21_260 VGND VGND VPWR VPWR sky130_fd_sc_hd__fill_2
XFILLER_21_271 VGND VGND VPWR VPWR sky130_fd_sc_hd__fill_1
XFILLER_107_321 VPWR VGND VPWR VGND sky130_ef_sc_hd__decap_12
XFILLER_107_365 VPWR VGND VPWR VGND sky130_ef_sc_hd__decap_12
XPHY_EDGE_ROW_57_Right_57 VGND VGND VPWR VPWR sky130_fd_sc_hd__decap_3
XFILLER_88_260 VGND VGND VPWR VPWR sky130_fd_sc_hd__fill_1
XFILLER_76_400 VPWR VGND VPWR VGND sky130_ef_sc_hd__decap_12
XFILLER_0_153 VGND VGND VPWR VPWR sky130_fd_sc_hd__decap_4
XFILLER_95_55 VGND VGND VPWR VPWR sky130_fd_sc_hd__fill_1
XFILLER_76_477 VPWR VGND VPWR VGND sky130_ef_sc_hd__decap_12
XTAP_TAPCELL_ROW_106_1401 VGND VPWR sky130_fd_sc_hd__tapvpwrvgnd_1
XFILLER_91_447 VGND VGND VPWR VPWR sky130_fd_sc_hd__fill_1
XPHY_EDGE_ROW_66_Right_66 VGND VGND VPWR VPWR sky130_fd_sc_hd__decap_3
XFILLER_71_182 VGND VGND VPWR VPWR sky130_fd_sc_hd__decap_3
XFILLER_44_396 VGND VGND VPWR VPWR sky130_fd_sc_hd__decap_3
XFILLER_8_220 VPWR VGND VPWR VGND sky130_ef_sc_hd__decap_12
XFILLER_8_253 VPWR VGND VPWR VGND sky130_ef_sc_hd__decap_12
X_2660_ _2660_/A _2660_/B VGND VGND VPWR VPWR _2661_/B sky130_fd_sc_hd__nand2_1
XFILLER_99_503 VGND VGND VPWR VPWR sky130_fd_sc_hd__fill_1
XPHY_EDGE_ROW_75_Right_75 VGND VGND VPWR VPWR sky130_fd_sc_hd__decap_3
X_2591_ _4559_/Q _4591_/Q _4623_/Q hold86/A _3278_/A _3278_/B VGND VGND VPWR VPWR
+ _2593_/B sky130_fd_sc_hd__mux4_1
X_4330_ _4742_/Q _4331_/A2 _3391_/A _4331_/B2 VGND VGND VPWR VPWR _4742_/D sky130_fd_sc_hd__a22o_1
X_4261_ _2199_/Y _4258_/Y _4265_/B VGND VGND VPWR VPWR _4262_/B sky130_fd_sc_hd__o21a_1
XPHY_EDGE_ROW_105_Left_213 VGND VGND VPWR VPWR sky130_fd_sc_hd__decap_3
X_3212_ _4547_/Q _4551_/Q VGND VGND VPWR VPWR _3212_/Y sky130_fd_sc_hd__nor2_1
XFILLER_79_293 VGND VGND VPWR VPWR sky130_fd_sc_hd__decap_4
X_4192_ _4213_/A1 _4190_/Y _4191_/X _4217_/B1 hold268/X VGND VGND VPWR VPWR _4695_/D
+ sky130_fd_sc_hd__a32o_1
XFILLER_39_102 VGND VGND VPWR VPWR sky130_fd_sc_hd__decap_8
XFILLER_39_113 VPWR VGND VPWR VGND sky130_ef_sc_hd__decap_12
X_3143_ _3141_/B _3141_/C _4547_/Q VGND VGND VPWR VPWR _3144_/B sky130_fd_sc_hd__a21oi_1
XFILLER_27_308 VGND VGND VPWR VPWR sky130_fd_sc_hd__decap_6
XFILLER_55_617 VPWR VGND VPWR VGND sky130_ef_sc_hd__decap_12
XPHY_EDGE_ROW_84_Right_84 VGND VGND VPWR VPWR sky130_fd_sc_hd__decap_3
XFILLER_82_403 VGND VGND VPWR VPWR sky130_fd_sc_hd__decap_4
X_3074_ _4512_/Q _3074_/B VGND VGND VPWR VPWR _3105_/A sky130_fd_sc_hd__xor2_4
XFILLER_54_127 VPWR VGND VPWR VGND sky130_ef_sc_hd__decap_12
XFILLER_82_469 VGND VGND VPWR VPWR sky130_fd_sc_hd__decap_6
XTAP_TAPCELL_ROW_25_509 VGND VPWR sky130_fd_sc_hd__tapvpwrvgnd_1
XTAP_TAPCELL_ROW_53_818 VGND VPWR sky130_fd_sc_hd__tapvpwrvgnd_1
XTAP_TAPCELL_ROW_81_1128 VGND VPWR sky130_fd_sc_hd__tapvpwrvgnd_1
XFILLER_24_29 VPWR VGND VPWR VGND sky130_ef_sc_hd__decap_12
X_3976_ _3976_/A _3976_/B VGND VGND VPWR VPWR _3976_/Y sky130_fd_sc_hd__nor2_1
XTAP_TAPCELL_ROW_33_597 VGND VPWR sky130_fd_sc_hd__tapvpwrvgnd_1
X_2927_ _4506_/Q _2927_/B VGND VGND VPWR VPWR _2928_/B sky130_fd_sc_hd__nor2_1
XFILLER_50_399 VGND VGND VPWR VPWR sky130_fd_sc_hd__decap_4
XPHY_EDGE_ROW_93_Right_93 VGND VGND VPWR VPWR sky130_fd_sc_hd__decap_3
X_2858_ hold262/X _2983_/A2 _3648_/A _4339_/B2 VGND VGND VPWR VPWR _4503_/D sky130_fd_sc_hd__a22o_1
Xhold220 _4494_/Q VGND VGND VPWR VPWR hold220/X sky130_fd_sc_hd__dlygate4sd3_1
X_2789_ _4747_/Q _2790_/B VGND VGND VPWR VPWR _2810_/C sky130_fd_sc_hd__or2_1
Xhold231 _4402_/Q VGND VGND VPWR VPWR hold231/X sky130_fd_sc_hd__dlygate4sd3_1
Xhold242 _4589_/Q VGND VGND VPWR VPWR hold242/X sky130_fd_sc_hd__dlygate4sd3_1
Xhold253 _4557_/Q VGND VGND VPWR VPWR hold253/X sky130_fd_sc_hd__dlygate4sd3_1
XFILLER_2_407 VGND VGND VPWR VPWR sky130_fd_sc_hd__decap_4
X_4528_ _4531_/CLK _4528_/D fanout150/X VGND VGND VPWR VPWR _4528_/Q sky130_fd_sc_hd__dfrtp_4
XTAP_TAPCELL_ROW_92_1246 VGND VPWR sky130_fd_sc_hd__tapvpwrvgnd_1
Xhold286 _4458_/Q VGND VGND VPWR VPWR hold286/X sky130_fd_sc_hd__dlygate4sd3_1
X_4459_ _4459_/CLK _4459_/D fanout159/X VGND VGND VPWR VPWR _4459_/Q sky130_fd_sc_hd__dfrtp_1
Xhold275 _4504_/Q VGND VGND VPWR VPWR hold275/X sky130_fd_sc_hd__dlygate4sd3_1
Xhold264 _4713_/Q VGND VGND VPWR VPWR hold264/X sky130_fd_sc_hd__dlygate4sd3_1
XFILLER_49_15 VPWR VGND VPWR VGND sky130_ef_sc_hd__decap_12
XFILLER_104_357 VGND VGND VPWR VPWR sky130_fd_sc_hd__decap_6
Xhold297 _4498_/Q VGND VGND VPWR VPWR hold297/X sky130_fd_sc_hd__dlygate4sd3_1
XTAP_TAPCELL_ROW_5_289 VGND VPWR sky130_fd_sc_hd__tapvpwrvgnd_1
XFILLER_46_606 VPWR VGND VPWR VGND sky130_ef_sc_hd__decap_12
XTAP_TAPCELL_ROW_69_995 VGND VPWR sky130_fd_sc_hd__tapvpwrvgnd_1
XFILLER_45_105 VGND VGND VPWR VPWR sky130_fd_sc_hd__fill_1
XFILLER_58_477 VPWR VGND VPWR VGND sky130_ef_sc_hd__decap_12
XFILLER_73_447 VGND VGND VPWR VPWR sky130_fd_sc_hd__fill_1
XFILLER_61_609 VGND VGND VPWR VPWR sky130_fd_sc_hd__decap_6
XFILLER_14_525 VGND VGND VPWR VPWR sky130_fd_sc_hd__decap_4
XFILLER_81_57 VPWR VGND VPWR VGND sky130_ef_sc_hd__decap_12
XFILLER_14_558 VPWR VGND VPWR VGND sky130_ef_sc_hd__decap_12
XFILLER_41_366 VGND VGND VPWR VPWR sky130_fd_sc_hd__decap_4
XTAP_TAPCELL_ROW_101_1342 VGND VPWR sky130_fd_sc_hd__tapvpwrvgnd_1
XFILLER_5_223 VGND VGND VPWR VPWR sky130_fd_sc_hd__fill_1
XFILLER_30_83 VGND VGND VPWR VPWR sky130_fd_sc_hd__fill_1
XFILLER_1_440 VGND VGND VPWR VPWR sky130_fd_sc_hd__decap_8
XFILLER_64_403 VGND VGND VPWR VPWR sky130_fd_sc_hd__decap_4
XFILLER_29_190 VGND VGND VPWR VPWR sky130_fd_sc_hd__fill_1
XFILLER_91_266 VGND VGND VPWR VPWR sky130_fd_sc_hd__fill_2
XFILLER_17_363 VGND VGND VPWR VPWR sky130_fd_sc_hd__decap_6
XFILLER_51_108 VGND VGND VPWR VPWR sky130_fd_sc_hd__decap_4
X_3830_ _3740_/A _3740_/B _3740_/C _3761_/A VGND VGND VPWR VPWR _3830_/X sky130_fd_sc_hd__a211o_1
X_3761_ _3761_/A _3761_/B VGND VGND VPWR VPWR _3762_/B sky130_fd_sc_hd__xor2_1
X_2712_ _2712_/A _2712_/B _2631_/B VGND VGND VPWR VPWR _2720_/A sky130_fd_sc_hd__or3b_1
XFILLER_9_540 VGND VGND VPWR VPWR sky130_fd_sc_hd__decap_4
XFILLER_72_3 VPWR VGND VPWR VGND sky130_ef_sc_hd__decap_12
X_3692_ _3693_/A _3693_/B VGND VGND VPWR VPWR _3692_/X sky130_fd_sc_hd__or2_1
XTAP_TAPCELL_ROW_30_567 VGND VPWR sky130_fd_sc_hd__tapvpwrvgnd_1
X_2643_ _2621_/B _2623_/B _2619_/X VGND VGND VPWR VPWR _2644_/B sky130_fd_sc_hd__a21o_1
X_2574_ _2574_/A _2574_/B VGND VGND VPWR VPWR _2576_/B sky130_fd_sc_hd__xnor2_1
XTAP_TAPCELL_ROW_78_1090 VGND VPWR sky130_fd_sc_hd__tapvpwrvgnd_1
X_4313_ _4313_/A VGND VGND VPWR VPWR _4313_/Y sky130_fd_sc_hd__inv_2
XFILLER_101_305 VPWR VGND VPWR VGND sky130_ef_sc_hd__decap_12
XFILLER_87_517 VPWR VGND VPWR VGND sky130_ef_sc_hd__decap_12
X_4244_ _4710_/Q _4246_/C VGND VGND VPWR VPWR _4244_/Y sky130_fd_sc_hd__nand2_1
XFILLER_101_349 VPWR VGND VPWR VGND sky130_ef_sc_hd__decap_12
XFILLER_95_561 VPWR VGND VPWR VGND sky130_ef_sc_hd__decap_12
X_4175_ _4206_/A1 _4173_/Y _4174_/X _4206_/B1 hold278/X VGND VGND VPWR VPWR _4690_/D
+ sky130_fd_sc_hd__a32o_1
X_3126_ _4514_/Q _3126_/B VGND VGND VPWR VPWR _3127_/B sky130_fd_sc_hd__or2_1
XFILLER_82_233 VGND VGND VPWR VPWR sky130_fd_sc_hd__decap_4
XFILLER_67_296 VGND VGND VPWR VPWR sky130_fd_sc_hd__decap_6
XTAP_TAPCELL_ROW_66_954 VGND VPWR sky130_fd_sc_hd__tapvpwrvgnd_1
XTAP_TAPCELL_ROW_2_259 VGND VPWR sky130_fd_sc_hd__tapvpwrvgnd_1
XTAP_TAPCELL_ROW_38_645 VGND VPWR sky130_fd_sc_hd__tapvpwrvgnd_1
XFILLER_55_447 VGND VGND VPWR VPWR sky130_fd_sc_hd__fill_1
X_3057_ _4579_/Q _4611_/Q _4643_/Q _4675_/Q _3246_/S0 _3246_/S1 VGND VGND VPWR VPWR
+ _3059_/B sky130_fd_sc_hd__mux4_1
XFILLER_35_39 VPWR VGND VPWR VGND sky130_ef_sc_hd__decap_12
XFILLER_50_130 VGND VGND VPWR VPWR sky130_fd_sc_hd__fill_2
XFILLER_50_174 VGND VGND VPWR VPWR sky130_fd_sc_hd__fill_2
XFILLER_51_27 VPWR VGND VPWR VGND sky130_ef_sc_hd__decap_12
X_3959_ _2221_/Y _3938_/B _4766_/Q VGND VGND VPWR VPWR _3960_/B sky130_fd_sc_hd__o21ba_1
XFILLER_104_121 VPWR VGND VPWR VGND sky130_ef_sc_hd__decap_12
XFILLER_2_237 VGND VGND VPWR VPWR sky130_fd_sc_hd__fill_1
XFILLER_104_165 VPWR VGND VPWR VGND sky130_ef_sc_hd__decap_12
XFILLER_46_425 VGND VGND VPWR VPWR sky130_fd_sc_hd__fill_1
XFILLER_58_263 VGND VGND VPWR VPWR sky130_fd_sc_hd__decap_6
XFILLER_73_233 VGND VGND VPWR VPWR sky130_fd_sc_hd__decap_4
XFILLER_73_277 VGND VGND VPWR VPWR sky130_fd_sc_hd__decap_3
XFILLER_73_255 VGND VGND VPWR VPWR sky130_fd_sc_hd__fill_1
XFILLER_73_299 VGND VGND VPWR VPWR sky130_fd_sc_hd__decap_3
XFILLER_14_377 VGND VGND VPWR VPWR sky130_fd_sc_hd__decap_8
XFILLER_6_587 VGND VGND VPWR VPWR sky130_fd_sc_hd__fill_1
XFILLER_69_517 VPWR VGND VPWR VGND sky130_ef_sc_hd__decap_12
X_2290_ _4685_/Q _2181_/Y _4686_/Q _2182_/Y VGND VGND VPWR VPWR _2290_/X sky130_fd_sc_hd__o22a_1
XFILLER_77_561 VPWR VGND VPWR VGND sky130_ef_sc_hd__decap_12
XFILLER_2_65 VPWR VGND VPWR VGND sky130_ef_sc_hd__decap_12
XFILLER_49_252 VGND VGND VPWR VPWR sky130_fd_sc_hd__decap_8
XFILLER_92_531 VGND VGND VPWR VPWR sky130_fd_sc_hd__fill_1
XFILLER_64_222 VGND VGND VPWR VPWR sky130_fd_sc_hd__decap_6
XFILLER_37_447 VGND VGND VPWR VPWR sky130_fd_sc_hd__fill_1
XFILLER_64_244 VGND VGND VPWR VPWR sky130_fd_sc_hd__decap_8
XFILLER_64_288 VGND VGND VPWR VPWR sky130_fd_sc_hd__fill_1
XTAP_TAPCELL_ROW_63_924 VGND VPWR sky130_fd_sc_hd__tapvpwrvgnd_1
XTAP_TAPCELL_ROW_35_615 VGND VPWR sky130_fd_sc_hd__tapvpwrvgnd_1
XFILLER_17_193 VGND VGND VPWR VPWR sky130_fd_sc_hd__fill_1
X_3813_ _4545_/Q _3813_/A2 _3812_/Y _3978_/A VGND VGND VPWR VPWR _4545_/D sky130_fd_sc_hd__a22o_1
XTAP_TAPCELL_ROW_15_394 VGND VPWR sky130_fd_sc_hd__tapvpwrvgnd_1
X_3744_ _4542_/Q _3744_/B VGND VGND VPWR VPWR _3745_/B sky130_fd_sc_hd__nor2_1
X_3675_ _3676_/B _3676_/C _3676_/A VGND VGND VPWR VPWR _3677_/B sky130_fd_sc_hd__a21o_1
XFILLER_106_419 VGND VGND VPWR VPWR sky130_fd_sc_hd__fill_1
X_2626_ hold87/A _4593_/Q hold88/A hold99/A _3257_/A _2747_/A VGND VGND VPWR VPWR
+ _2628_/B sky130_fd_sc_hd__mux4_1
XTAP_TAPCELL_ROW_7_307 VGND VPWR sky130_fd_sc_hd__tapvpwrvgnd_1
X_2557_ hold213/X _2432_/A _2555_/B _2558_/B _4480_/Q VGND VGND VPWR VPWR _4480_/D
+ sky130_fd_sc_hd__a32o_1
XFILLER_102_625 VPWR VGND VPWR VGND sky130_ef_sc_hd__decap_12
XFILLER_101_113 VPWR VGND VPWR VGND sky130_ef_sc_hd__decap_12
X_2488_ _2488_/A _2488_/B VGND VGND VPWR VPWR _2492_/B sky130_fd_sc_hd__nor2_1
XFILLER_87_369 VGND VGND VPWR VPWR sky130_fd_sc_hd__decap_3
X_4227_ _4238_/A1 _4224_/Y _4226_/Y _4238_/B1 hold219/X VGND VGND VPWR VPWR _4705_/D
+ sky130_fd_sc_hd__a32o_1
XFILLER_95_391 VGND VGND VPWR VPWR sky130_fd_sc_hd__fill_1
X_4158_ _4206_/A1 _4206_/B1 _4685_/Q VGND VGND VPWR VPWR _4685_/D sky130_fd_sc_hd__mux2_1
XFILLER_28_425 VGND VGND VPWR VPWR sky130_fd_sc_hd__fill_1
XFILLER_46_27 VGND VGND VPWR VPWR sky130_fd_sc_hd__fill_1
XFILLER_83_553 VGND VGND VPWR VPWR sky130_fd_sc_hd__decap_6
X_3109_ _3033_/B _3105_/Y _3106_/X _3108_/Y VGND VGND VPWR VPWR _3128_/A sky130_fd_sc_hd__o211ai_4
X_4089_ hold114/X _4731_/Q _4093_/S VGND VGND VPWR VPWR _4624_/D sky130_fd_sc_hd__mux2_1
XTAP_TAPCELL_ROW_87_1189 VGND VPWR sky130_fd_sc_hd__tapvpwrvgnd_1
XFILLER_83_597 VPWR VGND VPWR VGND sky130_ef_sc_hd__decap_12
XFILLER_70_225 VGND VGND VPWR VPWR sky130_fd_sc_hd__decap_3
XFILLER_102_77 VGND VGND VPWR VPWR sky130_fd_sc_hd__decap_6
XFILLER_62_15 VPWR VGND VPWR VGND sky130_ef_sc_hd__decap_12
XFILLER_36_491 VGND VGND VPWR VPWR sky130_fd_sc_hd__fill_1
XFILLER_105_441 VGND VGND VPWR VPWR sky130_fd_sc_hd__decap_6
XFILLER_2_3 VPWR VGND VPWR VGND sky130_ef_sc_hd__decap_12
XFILLER_105_485 VPWR VGND VPWR VGND sky130_ef_sc_hd__decap_12
XFILLER_87_89 VGND VGND VPWR VPWR sky130_fd_sc_hd__fill_1
XFILLER_93_317 VGND VGND VPWR VPWR sky130_fd_sc_hd__decap_3
XFILLER_59_561 VPWR VGND VPWR VGND sky130_ef_sc_hd__decap_12
XFILLER_74_531 VGND VGND VPWR VPWR sky130_fd_sc_hd__fill_1
XFILLER_46_244 VGND VGND VPWR VPWR sky130_fd_sc_hd__fill_1
XFILLER_46_266 VPWR VGND VPWR VGND sky130_ef_sc_hd__decap_12
XFILLER_61_225 VGND VGND VPWR VPWR sky130_fd_sc_hd__decap_6
Xinput13 uio_in[5] VGND VGND VPWR VPWR input13/X sky130_fd_sc_hd__clkbuf_1
XTAP_TAPCELL_ROW_12_364 VGND VPWR sky130_fd_sc_hd__tapvpwrvgnd_1
XTAP_TAPCELL_ROW_40_673 VGND VPWR sky130_fd_sc_hd__tapvpwrvgnd_1
XFILLER_6_373 VPWR VGND VPWR VGND sky130_ef_sc_hd__decap_12
X_3460_ _3460_/A _3460_/B VGND VGND VPWR VPWR _3461_/B sky130_fd_sc_hd__nand2_1
XTAP_TAPCELL_ROW_75_1060 VGND VPWR sky130_fd_sc_hd__tapvpwrvgnd_1
X_2411_ hold237/X _2414_/A2 _2414_/B1 _4512_/Q VGND VGND VPWR VPWR _4426_/D sky130_fd_sc_hd__a22o_1
X_3391_ _3391_/A _3391_/B VGND VGND VPWR VPWR _3392_/B sky130_fd_sc_hd__or2_1
X_2342_ hold125/X _4785_/A _4323_/S VGND VGND VPWR VPWR _4359_/D sky130_fd_sc_hd__a21o_1
XFILLER_35_3 VPWR VGND VPWR VGND sky130_ef_sc_hd__decap_12
XFILLER_96_133 VGND VGND VPWR VPWR sky130_fd_sc_hd__decap_6
XFILLER_96_177 VPWR VGND VPWR VGND sky130_ef_sc_hd__decap_12
X_2273_ _2319_/B _2270_/X _2272_/X VGND VGND VPWR VPWR _2273_/Y sky130_fd_sc_hd__o21ai_1
X_4012_ _4012_/A _4012_/B VGND VGND VPWR VPWR _4095_/B sky130_fd_sc_hd__nor2_4
XFILLER_84_339 VPWR VGND VPWR VGND sky130_ef_sc_hd__decap_12
XFILLER_80_501 VPWR VGND VPWR VGND sky130_ef_sc_hd__decap_12
XFILLER_65_553 VGND VGND VPWR VPWR sky130_fd_sc_hd__decap_6
XTAP_TAPCELL_ROW_48_762 VGND VPWR sky130_fd_sc_hd__tapvpwrvgnd_1
XFILLER_65_597 VPWR VGND VPWR VGND sky130_ef_sc_hd__decap_12
XFILLER_80_545 VPWR VGND VPWR VGND sky130_ef_sc_hd__decap_12
XFILLER_80_589 VPWR VGND VPWR VGND sky130_ef_sc_hd__decap_12
XFILLER_32_29 VPWR VGND VPWR VGND sky130_ef_sc_hd__decap_12
X_3727_ _3727_/A _3727_/B VGND VGND VPWR VPWR _3728_/B sky130_fd_sc_hd__or2_1
X_3658_ _3656_/Y _3672_/B VGND VGND VPWR VPWR _3659_/B sky130_fd_sc_hd__nand2b_1
XFILLER_88_601 VPWR VGND VPWR VGND sky130_ef_sc_hd__decap_12
X_2609_ _4530_/Q _4525_/Q VGND VGND VPWR VPWR _2611_/A sky130_fd_sc_hd__nand2_1
X_3589_ _3588_/A _3588_/B _2325_/C VGND VGND VPWR VPWR _3589_/Y sky130_fd_sc_hd__a21oi_1
XFILLER_102_433 VPWR VGND VPWR VGND sky130_ef_sc_hd__decap_12
XFILLER_57_15 VPWR VGND VPWR VGND sky130_ef_sc_hd__decap_12
XFILLER_102_477 VPWR VGND VPWR VGND sky130_ef_sc_hd__decap_12
XTAP_TAPCELL_ROW_89_1207 VGND VPWR sky130_fd_sc_hd__tapvpwrvgnd_1
XFILLER_56_531 VGND VGND VPWR VPWR sky130_fd_sc_hd__fill_1
XFILLER_71_501 VGND VGND VPWR VPWR sky130_fd_sc_hd__decap_3
XFILLER_83_361 VPWR VGND VPWR VGND sky130_ef_sc_hd__decap_12
XFILLER_28_288 VGND VGND VPWR VPWR sky130_fd_sc_hd__fill_1
XFILLER_73_69 VGND VGND VPWR VPWR sky130_fd_sc_hd__decap_8
XFILLER_24_472 VGND VGND VPWR VPWR sky130_fd_sc_hd__decap_4
XFILLER_98_77 VGND VGND VPWR VPWR sky130_fd_sc_hd__decap_6
XFILLER_3_387 VGND VGND VPWR VPWR sky130_fd_sc_hd__decap_4
XFILLER_105_293 VPWR VGND VPWR VGND sky130_ef_sc_hd__decap_12
XFILLER_78_177 VPWR VGND VPWR VGND sky130_ef_sc_hd__decap_12
XFILLER_93_169 VPWR VGND VPWR VGND sky130_ef_sc_hd__decap_12
XFILLER_47_81 VGND VGND VPWR VPWR sky130_fd_sc_hd__decap_4
XFILLER_62_501 VPWR VGND VPWR VGND sky130_ef_sc_hd__decap_12
XFILLER_19_288 VGND VGND VPWR VPWR sky130_fd_sc_hd__fill_1
XFILLER_34_225 VGND VGND VPWR VPWR sky130_fd_sc_hd__fill_2
XFILLER_47_586 VGND VGND VPWR VPWR sky130_fd_sc_hd__fill_2
XFILLER_62_545 VPWR VGND VPWR VGND sky130_ef_sc_hd__decap_12
XTAP_TAPCELL_ROW_17_423 VGND VPWR sky130_fd_sc_hd__tapvpwrvgnd_1
XTAP_TAPCELL_ROW_45_732 VGND VPWR sky130_fd_sc_hd__tapvpwrvgnd_1
XFILLER_62_589 VPWR VGND VPWR VGND sky130_ef_sc_hd__decap_12
X_2960_ _4754_/Q _2961_/B VGND VGND VPWR VPWR _3008_/A sky130_fd_sc_hd__and2_1
X_2891_ _2891_/A _2891_/B VGND VGND VPWR VPWR _2916_/B sky130_fd_sc_hd__or2_1
XFILLER_42_280 VGND VGND VPWR VPWR sky130_fd_sc_hd__decap_8
X_4630_ clkload7/A _4630_/D fanout124/X VGND VGND VPWR VPWR hold43/A sky130_fd_sc_hd__dfrtp_1
XFILLER_8_53 VPWR VGND VPWR VGND sky130_ef_sc_hd__decap_12
XFILLER_30_497 VGND VGND VPWR VPWR sky130_fd_sc_hd__fill_1
X_4561_ _4740_/CLK _4561_/D fanout122/X VGND VGND VPWR VPWR hold87/A sky130_fd_sc_hd__dfrtp_1
XFILLER_8_97 VGND VGND VPWR VPWR sky130_fd_sc_hd__decap_6
X_4492_ _4739_/CLK _4492_/D fanout129/X VGND VGND VPWR VPWR _4492_/Q sky130_fd_sc_hd__dfrtp_2
X_3512_ _3488_/Y _3492_/Y _3511_/Y VGND VGND VPWR VPWR _3512_/Y sky130_fd_sc_hd__a21oi_1
X_3443_ _3443_/A _3443_/B VGND VGND VPWR VPWR _3445_/B sky130_fd_sc_hd__xnor2_2
X_3374_ _3374_/A _3374_/B VGND VGND VPWR VPWR _3376_/B sky130_fd_sc_hd__nand2_1
XFILLER_85_615 VGND VGND VPWR VPWR sky130_fd_sc_hd__fill_1
X_2325_ _4480_/Q _4481_/Q _2325_/C VGND VGND VPWR VPWR _2432_/A sky130_fd_sc_hd__nor3_4
XFILLER_97_497 VGND VGND VPWR VPWR sky130_fd_sc_hd__decap_6
X_2256_ _4368_/Q _2256_/B VGND VGND VPWR VPWR _2258_/A sky130_fd_sc_hd__nand2_1
XFILLER_38_531 VGND VGND VPWR VPWR sky130_fd_sc_hd__fill_1
XFILLER_38_542 VGND VGND VPWR VPWR sky130_fd_sc_hd__fill_1
X_2187_ hold66/A VGND VGND VPWR VPWR _2449_/A sky130_fd_sc_hd__inv_2
XFILLER_25_214 VGND VGND VPWR VPWR sky130_fd_sc_hd__fill_1
XFILLER_38_575 VPWR VGND VPWR VGND sky130_ef_sc_hd__decap_12
XFILLER_92_191 VGND VGND VPWR VPWR sky130_fd_sc_hd__decap_4
XTAP_TAPCELL_ROW_84_1159 VGND VPWR sky130_fd_sc_hd__tapvpwrvgnd_1
XFILLER_25_225 VGND VGND VPWR VPWR sky130_fd_sc_hd__decap_8
XFILLER_53_545 VPWR VGND VPWR VGND sky130_ef_sc_hd__decap_12
XFILLER_40_217 VGND VGND VPWR VPWR sky130_fd_sc_hd__fill_2
XFILLER_43_39 VPWR VGND VPWR VGND sky130_ef_sc_hd__decap_12
XFILLER_21_453 VGND VGND VPWR VPWR sky130_fd_sc_hd__fill_1
XFILLER_21_497 VGND VGND VPWR VPWR sky130_fd_sc_hd__decap_6
X_4759_ _4761_/CLK _4759_/D fanout140/X VGND VGND VPWR VPWR _4759_/Q sky130_fd_sc_hd__dfrtp_1
XTAP_TAPCELL_ROW_95_1277 VGND VPWR sky130_fd_sc_hd__tapvpwrvgnd_1
XFILLER_88_475 VGND VGND VPWR VPWR sky130_fd_sc_hd__fill_1
XFILLER_48_328 VGND VGND VPWR VPWR sky130_fd_sc_hd__fill_1
XFILLER_29_542 VGND VGND VPWR VPWR sky130_fd_sc_hd__decap_3
XTAP_TAPCELL_ROW_59_879 VGND VPWR sky130_fd_sc_hd__tapvpwrvgnd_1
XFILLER_91_629 VGND VGND VPWR VPWR sky130_fd_sc_hd__decap_8
XFILLER_29_575 VGND VGND VPWR VPWR sky130_fd_sc_hd__fill_2
XFILLER_17_51 VGND VGND VPWR VPWR sky130_fd_sc_hd__decap_4
XFILLER_44_589 VGND VGND VPWR VPWR sky130_fd_sc_hd__decap_8
XTAP_TAPCELL_ROW_104_1373 VGND VPWR sky130_fd_sc_hd__tapvpwrvgnd_1
XFILLER_71_397 VGND VGND VPWR VPWR sky130_fd_sc_hd__fill_1
XFILLER_12_431 VGND VGND VPWR VPWR sky130_fd_sc_hd__fill_1
XTAP_TAPCELL_ROW_22_470 VGND VPWR sky130_fd_sc_hd__tapvpwrvgnd_1
XFILLER_79_420 VGND VGND VPWR VPWR sky130_fd_sc_hd__fill_1
XFILLER_94_401 VPWR VGND VPWR VGND sky130_ef_sc_hd__decap_12
XFILLER_67_615 VGND VGND VPWR VPWR sky130_fd_sc_hd__fill_1
XFILLER_94_445 VPWR VGND VPWR VGND sky130_ef_sc_hd__decap_12
XFILLER_79_497 VGND VGND VPWR VPWR sky130_fd_sc_hd__decap_6
X_3090_ _4541_/Q _4550_/Q VGND VGND VPWR VPWR _3092_/C sky130_fd_sc_hd__nand2_1
Xhold2 hold2/A VGND VGND VPWR VPWR hold2/X sky130_fd_sc_hd__dlygate4sd3_1
XFILLER_54_309 VPWR VGND VPWR VGND sky130_ef_sc_hd__decap_12
XFILLER_94_489 VPWR VGND VPWR VGND sky130_ef_sc_hd__decap_12
XFILLER_35_501 VGND VGND VPWR VPWR sky130_fd_sc_hd__decap_3
XFILLER_35_512 VGND VGND VPWR VPWR sky130_fd_sc_hd__fill_1
XFILLER_62_320 VGND VGND VPWR VPWR sky130_fd_sc_hd__decap_8
X_3992_ _3990_/Y _3991_/X hold4/A _4355_/A2 VGND VGND VPWR VPWR _4553_/D sky130_fd_sc_hd__a2bb2o_1
X_2943_ _4535_/Q _3791_/A VGND VGND VPWR VPWR _2944_/C sky130_fd_sc_hd__nand2_1
XFILLER_30_250 VGND VGND VPWR VPWR sky130_fd_sc_hd__fill_2
X_2874_ _2874_/A _2874_/B VGND VGND VPWR VPWR _2876_/B sky130_fd_sc_hd__xnor2_1
X_4613_ _4679_/CLK _4613_/D fanout138/X VGND VGND VPWR VPWR hold48/A sky130_fd_sc_hd__dfrtp_1
X_4544_ _4547_/CLK _4544_/D fanout170/X VGND VGND VPWR VPWR _4544_/Q sky130_fd_sc_hd__dfrtp_1
X_4475_ _4538_/CLK _4475_/D fanout172/X VGND VGND VPWR VPWR _4475_/Q sky130_fd_sc_hd__dfrtp_1
Xstream_cipher_178 VGND VGND VPWR VPWR stream_cipher_178/HI uio_oe[6] sky130_fd_sc_hd__conb_1
X_3426_ _3407_/A _3407_/B _3403_/X VGND VGND VPWR VPWR _3427_/B sky130_fd_sc_hd__a21o_1
XFILLER_97_261 VPWR VGND VPWR VGND sky130_ef_sc_hd__decap_12
X_3357_ _4526_/Q _3357_/B _3357_/C VGND VGND VPWR VPWR _3357_/Y sky130_fd_sc_hd__nand3_1
X_2308_ _2471_/A _4697_/Q _4454_/Q _4201_/A VGND VGND VPWR VPWR _2311_/B sky130_fd_sc_hd__o2bb2a_1
XFILLER_57_125 VGND VGND VPWR VPWR sky130_fd_sc_hd__fill_2
X_3288_ _3278_/B _3287_/B _3286_/X _3270_/B _3278_/A VGND VGND VPWR VPWR _3304_/B
+ sky130_fd_sc_hd__a2111o_1
XFILLER_73_629 VGND VGND VPWR VPWR sky130_fd_sc_hd__decap_8
XFILLER_26_523 VGND VGND VPWR VPWR sky130_fd_sc_hd__fill_1
X_2239_ hold58/A _4364_/Q hold10/X VGND VGND VPWR VPWR _4370_/D sky130_fd_sc_hd__o21a_1
XFILLER_54_27 VGND VGND VPWR VPWR sky130_fd_sc_hd__fill_1
XTAP_TAPCELL_ROW_56_849 VGND VPWR sky130_fd_sc_hd__tapvpwrvgnd_1
XFILLER_53_353 VGND VGND VPWR VPWR sky130_fd_sc_hd__fill_1
XFILLER_70_15 VPWR VGND VPWR VGND sky130_ef_sc_hd__decap_12
XFILLER_5_416 VPWR VGND VPWR VGND sky130_ef_sc_hd__decap_12
XFILLER_107_333 VGND VGND VPWR VPWR sky130_fd_sc_hd__decap_3
XFILLER_5_449 VGND VGND VPWR VPWR sky130_fd_sc_hd__fill_2
XFILLER_107_377 VPWR VGND VPWR VGND sky130_ef_sc_hd__decap_12
XFILLER_102_3 VPWR VGND VPWR VGND sky130_ef_sc_hd__decap_12
XFILLER_79_57 VPWR VGND VPWR VGND sky130_ef_sc_hd__decap_12
XFILLER_0_121 VGND VGND VPWR VPWR sky130_fd_sc_hd__decap_3
XFILLER_103_561 VPWR VGND VPWR VGND sky130_ef_sc_hd__decap_12
XFILLER_49_615 VGND VGND VPWR VPWR sky130_fd_sc_hd__fill_1
XFILLER_76_412 VGND VGND VPWR VPWR sky130_fd_sc_hd__decap_8
XFILLER_0_187 VGND VGND VPWR VPWR sky130_fd_sc_hd__fill_1
XFILLER_48_114 VGND VGND VPWR VPWR sky130_fd_sc_hd__decap_6
XTAP_TAPCELL_ROW_106_1402 VGND VPWR sky130_fd_sc_hd__tapvpwrvgnd_1
XFILLER_76_489 VPWR VGND VPWR VGND sky130_ef_sc_hd__decap_12
XFILLER_28_83 VGND VGND VPWR VPWR sky130_fd_sc_hd__fill_1
XFILLER_29_383 VGND VGND VPWR VPWR sky130_fd_sc_hd__decap_8
XFILLER_8_232 VGND VGND VPWR VPWR sky130_fd_sc_hd__decap_6
XFILLER_8_265 VPWR VGND VPWR VGND sky130_ef_sc_hd__decap_12
X_2590_ _2581_/A _2581_/B _2579_/X _3278_/B VGND VGND VPWR VPWR _2595_/A sky130_fd_sc_hd__a2bb2o_1
XFILLER_99_559 VGND VGND VPWR VPWR sky130_fd_sc_hd__fill_1
X_4260_ _4265_/B _4258_/Y _4259_/X _4262_/A _4714_/Q VGND VGND VPWR VPWR _4714_/D
+ sky130_fd_sc_hd__a32o_1
X_3211_ _3201_/B _3203_/B _3201_/A VGND VGND VPWR VPWR _3215_/A sky130_fd_sc_hd__o21ba_1
XFILLER_67_401 VGND VGND VPWR VPWR sky130_fd_sc_hd__fill_2
X_4191_ _4695_/Q _4194_/C VGND VGND VPWR VPWR _4191_/X sky130_fd_sc_hd__or2_1
X_3142_ _3142_/A VGND VGND VPWR VPWR _3144_/A sky130_fd_sc_hd__inv_2
XFILLER_39_125 VGND VGND VPWR VPWR sky130_fd_sc_hd__decap_6
XFILLER_94_253 VPWR VGND VPWR VGND sky130_ef_sc_hd__decap_12
XFILLER_67_445 VGND VGND VPWR VPWR sky130_fd_sc_hd__decap_3
X_3073_ _4512_/Q _3074_/B VGND VGND VPWR VPWR _3100_/A sky130_fd_sc_hd__nand2_1
XFILLER_55_629 VGND VGND VPWR VPWR sky130_fd_sc_hd__decap_8
XFILLER_47_180 VGND VGND VPWR VPWR sky130_fd_sc_hd__fill_2
XFILLER_54_139 VGND VGND VPWR VPWR sky130_fd_sc_hd__fill_1
XFILLER_62_150 VGND VGND VPWR VPWR sky130_fd_sc_hd__decap_6
XTAP_TAPCELL_ROW_53_819 VGND VPWR sky130_fd_sc_hd__tapvpwrvgnd_1
XTAP_TAPCELL_ROW_81_1118 VGND VPWR sky130_fd_sc_hd__tapvpwrvgnd_1
X_3975_ _3956_/B _3974_/X _3954_/B VGND VGND VPWR VPWR _3976_/B sky130_fd_sc_hd__o21ba_1
X_2926_ _4506_/Q _2927_/B VGND VGND VPWR VPWR _2928_/A sky130_fd_sc_hd__and2_1
XTAP_TAPCELL_ROW_33_598 VGND VPWR sky130_fd_sc_hd__tapvpwrvgnd_1
X_2857_ _2835_/A _2854_/Y _2878_/B _2878_/C VGND VGND VPWR VPWR _3648_/A sky130_fd_sc_hd__o211a_2
XFILLER_40_29 VPWR VGND VPWR VGND sky130_ef_sc_hd__decap_12
X_2788_ hold69/A _4600_/Q hold64/A _4664_/Q _2746_/S _2747_/A VGND VGND VPWR VPWR
+ _2790_/B sky130_fd_sc_hd__mux4_1
Xhold210 _4425_/Q VGND VGND VPWR VPWR hold210/X sky130_fd_sc_hd__dlygate4sd3_1
Xhold221 _2393_/X VGND VGND VPWR VPWR _4408_/D sky130_fd_sc_hd__dlygate4sd3_1
X_4527_ _4527_/CLK _4527_/D fanout146/X VGND VGND VPWR VPWR _4527_/Q sky130_fd_sc_hd__dfrtp_1
Xhold232 _4404_/Q VGND VGND VPWR VPWR hold232/X sky130_fd_sc_hd__dlygate4sd3_1
Xhold243 _4477_/Q VGND VGND VPWR VPWR hold243/X sky130_fd_sc_hd__dlygate4sd3_1
XTAP_TAPCELL_ROW_92_1247 VGND VPWR sky130_fd_sc_hd__tapvpwrvgnd_1
Xhold265 _4759_/Q VGND VGND VPWR VPWR hold265/X sky130_fd_sc_hd__dlygate4sd3_1
Xhold254 _4558_/Q VGND VGND VPWR VPWR hold254/X sky130_fd_sc_hd__dlygate4sd3_1
X_4458_ _4699_/CLK _4458_/D fanout159/X VGND VGND VPWR VPWR _4458_/Q sky130_fd_sc_hd__dfrtp_1
XFILLER_49_27 VPWR VGND VPWR VGND sky130_ef_sc_hd__decap_12
Xhold276 _4475_/Q VGND VGND VPWR VPWR hold276/X sky130_fd_sc_hd__dlygate4sd3_1
Xhold287 _4507_/Q VGND VGND VPWR VPWR hold287/X sky130_fd_sc_hd__dlygate4sd3_1
X_3409_ _4743_/Q _3409_/B VGND VGND VPWR VPWR _3412_/A sky130_fd_sc_hd__xnor2_1
Xhold298 _4701_/Q VGND VGND VPWR VPWR hold298/X sky130_fd_sc_hd__dlygate4sd3_1
XFILLER_98_581 VGND VGND VPWR VPWR sky130_fd_sc_hd__decap_6
X_4389_ _4532_/CLK _4389_/D fanout153/X VGND VGND VPWR VPWR hold36/A sky130_fd_sc_hd__dfrtp_1
XFILLER_105_55 VGND VGND VPWR VPWR sky130_fd_sc_hd__fill_1
XFILLER_100_531 VGND VGND VPWR VPWR sky130_fd_sc_hd__fill_1
XFILLER_65_15 VPWR VGND VPWR VGND sky130_ef_sc_hd__decap_12
XTAP_TAPCELL_ROW_69_996 VGND VPWR sky130_fd_sc_hd__tapvpwrvgnd_1
XFILLER_46_618 VPWR VGND VPWR VGND sky130_ef_sc_hd__decap_12
XFILLER_58_489 VPWR VGND VPWR VGND sky130_ef_sc_hd__decap_12
XFILLER_45_128 VGND VGND VPWR VPWR sky130_fd_sc_hd__decap_3
XFILLER_81_69 VGND VGND VPWR VPWR sky130_fd_sc_hd__decap_3
XFILLER_41_345 VGND VGND VPWR VPWR sky130_fd_sc_hd__fill_1
XTAP_TAPCELL_ROW_101_1343 VGND VPWR sky130_fd_sc_hd__tapvpwrvgnd_1
XFILLER_14_41 VPWR VGND VPWR VGND sky130_ef_sc_hd__decap_12
XFILLER_14_85 VPWR VGND VPWR VGND sky130_ef_sc_hd__decap_12
XFILLER_5_202 VGND VGND VPWR VPWR sky130_fd_sc_hd__decap_8
XFILLER_107_141 VGND VGND VPWR VPWR sky130_fd_sc_hd__fill_1
XFILLER_103_391 VGND VGND VPWR VPWR sky130_fd_sc_hd__fill_1
XFILLER_76_286 VPWR VGND VPWR VGND sky130_ef_sc_hd__decap_12
XFILLER_91_223 VGND VGND VPWR VPWR sky130_fd_sc_hd__fill_1
XFILLER_17_320 VGND VGND VPWR VPWR sky130_fd_sc_hd__fill_2
XFILLER_55_81 VGND VGND VPWR VPWR sky130_fd_sc_hd__fill_1
XFILLER_17_386 VGND VGND VPWR VPWR sky130_fd_sc_hd__decap_6
XFILLER_44_161 VGND VGND VPWR VPWR sky130_fd_sc_hd__decap_8
X_3760_ _3778_/A _3776_/C VGND VGND VPWR VPWR _3761_/B sky130_fd_sc_hd__nand2_1
X_2711_ _2711_/A _2711_/B _2711_/C VGND VGND VPWR VPWR _2712_/B sky130_fd_sc_hd__or3_1
XFILLER_9_574 VGND VGND VPWR VPWR sky130_fd_sc_hd__decap_3
XTAP_TAPCELL_ROW_30_557 VGND VPWR sky130_fd_sc_hd__tapvpwrvgnd_1
X_3691_ _3644_/A _3644_/B _3689_/Y _3690_/Y VGND VGND VPWR VPWR _3693_/B sky130_fd_sc_hd__o31ai_2
XFILLER_65_3 VPWR VGND VPWR VGND sky130_ef_sc_hd__decap_12
X_2642_ _4494_/Q _2642_/B VGND VGND VPWR VPWR _2644_/A sky130_fd_sc_hd__xor2_2
X_2573_ _2584_/A _2573_/B VGND VGND VPWR VPWR _2574_/B sky130_fd_sc_hd__nand2_1
XTAP_TAPCELL_ROW_78_1091 VGND VPWR sky130_fd_sc_hd__tapvpwrvgnd_1
X_4312_ _4410_/Q hold15/A _4426_/Q _4434_/Q _4319_/S0 _2427_/B VGND VGND VPWR VPWR
+ _4313_/A sky130_fd_sc_hd__mux4_1
X_4243_ _4710_/Q _4246_/C VGND VGND VPWR VPWR _4243_/X sky130_fd_sc_hd__or2_1
XFILLER_101_317 VPWR VGND VPWR VGND sky130_ef_sc_hd__decap_12
XFILLER_87_529 VPWR VGND VPWR VGND sky130_ef_sc_hd__decap_12
X_4174_ _4690_/Q _4176_/C VGND VGND VPWR VPWR _4174_/X sky130_fd_sc_hd__or2_1
XFILLER_95_573 VPWR VGND VPWR VGND sky130_ef_sc_hd__decap_12
X_3125_ _4514_/Q _3126_/B VGND VGND VPWR VPWR _3127_/A sky130_fd_sc_hd__nand2_1
XFILLER_28_618 VGND VGND VPWR VPWR sky130_fd_sc_hd__fill_2
XTAP_TAPCELL_ROW_66_955 VGND VPWR sky130_fd_sc_hd__tapvpwrvgnd_1
XTAP_TAPCELL_ROW_2_249 VGND VPWR sky130_fd_sc_hd__tapvpwrvgnd_1
XTAP_TAPCELL_ROW_38_646 VGND VPWR sky130_fd_sc_hd__tapvpwrvgnd_1
XFILLER_55_426 VGND VGND VPWR VPWR sky130_fd_sc_hd__decap_8
X_3056_ _4511_/Q _3081_/A2 _3858_/A _4355_/B2 VGND VGND VPWR VPWR _4511_/D sky130_fd_sc_hd__a22o_1
XFILLER_70_418 VGND VGND VPWR VPWR sky130_fd_sc_hd__fill_2
XFILLER_50_120 VGND VGND VPWR VPWR sky130_fd_sc_hd__fill_1
XFILLER_50_153 VGND VGND VPWR VPWR sky130_fd_sc_hd__fill_1
X_3958_ _4764_/Q _3913_/B _4766_/Q _4765_/Q VGND VGND VPWR VPWR _3984_/B sky130_fd_sc_hd__o211a_1
XFILLER_50_197 VGND VGND VPWR VPWR sky130_fd_sc_hd__decap_8
XFILLER_51_39 VPWR VGND VPWR VGND sky130_ef_sc_hd__decap_12
X_3889_ _3889_/A _3889_/B _3889_/C VGND VGND VPWR VPWR _3889_/X sky130_fd_sc_hd__or3_1
X_2909_ _2813_/A _2842_/A _2865_/A _2892_/B _2908_/Y VGND VGND VPWR VPWR _2909_/X
+ sky130_fd_sc_hd__o41a_1
XFILLER_104_133 VGND VGND VPWR VPWR sky130_fd_sc_hd__decap_6
XFILLER_104_177 VPWR VGND VPWR VGND sky130_ef_sc_hd__decap_12
XFILLER_58_253 VGND VGND VPWR VPWR sky130_fd_sc_hd__decap_6
XFILLER_18_139 VGND VGND VPWR VPWR sky130_fd_sc_hd__fill_1
XFILLER_58_286 VPWR VGND VPWR VGND sky130_ef_sc_hd__decap_12
XFILLER_54_470 VGND VGND VPWR VPWR sky130_fd_sc_hd__decap_6
XFILLER_25_51 VGND VGND VPWR VPWR sky130_fd_sc_hd__decap_4
XFILLER_10_551 VPWR VGND VPWR VGND sky130_ef_sc_hd__decap_12
XFILLER_6_500 VPWR VGND VPWR VGND sky130_ef_sc_hd__decap_12
XFILLER_6_544 VGND VGND VPWR VPWR sky130_fd_sc_hd__decap_6
XFILLER_69_529 VPWR VGND VPWR VGND sky130_ef_sc_hd__decap_12
XFILLER_77_573 VPWR VGND VPWR VGND sky130_ef_sc_hd__decap_12
XFILLER_2_77 VGND VGND VPWR VPWR sky130_fd_sc_hd__decap_6
XFILLER_49_275 VGND VGND VPWR VPWR sky130_fd_sc_hd__fill_1
XFILLER_92_587 VGND VGND VPWR VPWR sky130_fd_sc_hd__fill_1
XTAP_TAPCELL_ROW_63_925 VGND VPWR sky130_fd_sc_hd__tapvpwrvgnd_1
XFILLER_24_109 VGND VGND VPWR VPWR sky130_fd_sc_hd__decap_4
XTAP_TAPCELL_ROW_35_616 VGND VPWR sky130_fd_sc_hd__tapvpwrvgnd_1
XFILLER_45_492 VGND VGND VPWR VPWR sky130_fd_sc_hd__fill_2
X_3812_ _3838_/B _3812_/B VGND VGND VPWR VPWR _3812_/Y sky130_fd_sc_hd__xnor2_1
XTAP_TAPCELL_ROW_15_395 VGND VPWR sky130_fd_sc_hd__tapvpwrvgnd_1
X_3743_ _4542_/Q _3744_/B VGND VGND VPWR VPWR _3769_/A sky130_fd_sc_hd__and2_1
XFILLER_9_393 VPWR VGND VPWR VGND sky130_ef_sc_hd__decap_12
X_3674_ _3674_/A _3674_/B VGND VGND VPWR VPWR _3684_/A sky130_fd_sc_hd__xnor2_1
X_2625_ _4493_/Q _3277_/B2 _2624_/Y _2708_/B2 VGND VGND VPWR VPWR _4493_/D sky130_fd_sc_hd__a22o_1
XTAP_TAPCELL_ROW_7_308 VGND VPWR sky130_fd_sc_hd__tapvpwrvgnd_1
X_2556_ _2432_/A _2554_/Y _2555_/X _3470_/B2 hold213/X VGND VGND VPWR VPWR _4479_/D
+ sky130_fd_sc_hd__a32o_1
X_2487_ _2488_/A _2488_/B VGND VGND VPWR VPWR _2487_/Y sky130_fd_sc_hd__nand2_1
XFILLER_101_125 VPWR VGND VPWR VGND sky130_ef_sc_hd__decap_12
XFILLER_87_337 VPWR VGND VPWR VGND sky130_ef_sc_hd__decap_12
X_4226_ _4229_/B VGND VGND VPWR VPWR _4226_/Y sky130_fd_sc_hd__inv_2
XFILLER_101_169 VPWR VGND VPWR VGND sky130_ef_sc_hd__decap_12
X_4157_ _4149_/B _4030_/X _4095_/Y _4149_/Y hold97/X VGND VGND VPWR VPWR _4684_/D
+ sky130_fd_sc_hd__a32o_1
X_3108_ _3105_/A _3076_/Y _3105_/B _3107_/X _3097_/X VGND VGND VPWR VPWR _3108_/Y
+ sky130_fd_sc_hd__a32oi_4
XFILLER_28_437 VGND VGND VPWR VPWR sky130_fd_sc_hd__fill_1
X_4088_ hold104/X _4730_/Q _4093_/S VGND VGND VPWR VPWR _4623_/D sky130_fd_sc_hd__mux2_1
XFILLER_28_459 VGND VGND VPWR VPWR sky130_fd_sc_hd__fill_2
XFILLER_55_256 VGND VGND VPWR VPWR sky130_fd_sc_hd__fill_2
X_3039_ _3037_/Y _3039_/B VGND VGND VPWR VPWR _3061_/B sky130_fd_sc_hd__nand2b_2
XFILLER_36_470 VGND VGND VPWR VPWR sky130_fd_sc_hd__fill_2
XFILLER_43_429 VPWR VGND VPWR VGND sky130_ef_sc_hd__decap_12
XFILLER_62_27 VGND VGND VPWR VPWR sky130_fd_sc_hd__fill_1
XFILLER_3_536 VGND VGND VPWR VPWR sky130_fd_sc_hd__decap_4
XFILLER_105_497 VGND VGND VPWR VPWR sky130_fd_sc_hd__decap_6
XFILLER_87_57 VPWR VGND VPWR VGND sky130_ef_sc_hd__decap_12
XFILLER_59_573 VPWR VGND VPWR VGND sky130_ef_sc_hd__decap_12
XFILLER_46_201 VGND VGND VPWR VPWR sky130_fd_sc_hd__fill_1
XFILLER_74_587 VGND VGND VPWR VPWR sky130_fd_sc_hd__fill_1
XFILLER_61_204 VPWR VGND VPWR VGND sky130_ef_sc_hd__decap_12
XFILLER_34_418 VGND VGND VPWR VPWR sky130_fd_sc_hd__fill_2
XFILLER_46_278 VGND VGND VPWR VPWR sky130_fd_sc_hd__fill_1
XFILLER_36_83 VGND VGND VPWR VPWR sky130_fd_sc_hd__fill_1
XTAP_TAPCELL_ROW_12_365 VGND VPWR sky130_fd_sc_hd__tapvpwrvgnd_1
XTAP_TAPCELL_ROW_40_674 VGND VPWR sky130_fd_sc_hd__tapvpwrvgnd_1
XFILLER_6_352 VGND VGND VPWR VPWR sky130_fd_sc_hd__fill_1
XFILLER_6_385 VGND VGND VPWR VPWR sky130_fd_sc_hd__decap_4
X_2410_ hold210/X _2420_/A2 _2420_/B1 _4511_/Q VGND VGND VPWR VPWR _4425_/D sky130_fd_sc_hd__a22o_1
XTAP_TAPCELL_ROW_75_1061 VGND VPWR sky130_fd_sc_hd__tapvpwrvgnd_1
X_3390_ _3391_/A _3391_/B VGND VGND VPWR VPWR _3415_/A sky130_fd_sc_hd__nand2_1
X_2341_ _4556_/Q _4371_/Q VGND VGND VPWR VPWR _4323_/S sky130_fd_sc_hd__or2_4
XFILLER_69_337 VGND VGND VPWR VPWR sky130_fd_sc_hd__fill_1
X_2272_ _2202_/Y _4469_/Q _4250_/A _4468_/Q _2271_/X VGND VGND VPWR VPWR _2272_/X
+ sky130_fd_sc_hd__o221a_1
XFILLER_84_307 VGND VGND VPWR VPWR sky130_fd_sc_hd__fill_1
XFILLER_28_3 VPWR VGND VPWR VGND sky130_ef_sc_hd__decap_12
X_4011_ _4012_/A _4012_/B VGND VGND VPWR VPWR _4013_/B sky130_fd_sc_hd__or2_4
XFILLER_96_189 VGND VGND VPWR VPWR sky130_fd_sc_hd__decap_6
XTAP_TAPCELL_ROW_48_763 VGND VPWR sky130_fd_sc_hd__tapvpwrvgnd_1
XFILLER_80_513 VPWR VGND VPWR VGND sky130_ef_sc_hd__decap_12
XFILLER_80_557 VPWR VGND VPWR VGND sky130_ef_sc_hd__decap_12
XFILLER_52_237 VPWR VGND VPWR VGND sky130_ef_sc_hd__decap_12
X_3726_ _3727_/A _3727_/B VGND VGND VPWR VPWR _3776_/A sky130_fd_sc_hd__nand2_1
X_3657_ _3657_/A _3657_/B VGND VGND VPWR VPWR _3672_/B sky130_fd_sc_hd__nand2_1
X_2608_ _2598_/B _2600_/B _2598_/A VGND VGND VPWR VPWR _2612_/A sky130_fd_sc_hd__a21bo_1
X_3588_ _3588_/A _3588_/B VGND VGND VPWR VPWR _3588_/X sky130_fd_sc_hd__or2_1
XFILLER_102_401 VPWR VGND VPWR VGND sky130_ef_sc_hd__decap_12
XFILLER_88_613 VPWR VGND VPWR VGND sky130_ef_sc_hd__decap_12
XFILLER_0_517 VGND VGND VPWR VPWR sky130_fd_sc_hd__decap_3
X_2539_ _2432_/A _2537_/X _2538_/Y _3748_/B2 hold277/X VGND VGND VPWR VPWR _4474_/D
+ sky130_fd_sc_hd__a32o_1
XFILLER_102_445 VPWR VGND VPWR VGND sky130_ef_sc_hd__decap_12
XTAP_TAPCELL_ROW_89_1208 VGND VPWR sky130_fd_sc_hd__tapvpwrvgnd_1
XFILLER_57_27 VPWR VGND VPWR VGND sky130_ef_sc_hd__decap_12
XFILLER_102_489 VPWR VGND VPWR VGND sky130_ef_sc_hd__decap_12
XFILLER_68_381 VGND VGND VPWR VPWR sky130_fd_sc_hd__fill_1
X_4209_ _4212_/B VGND VGND VPWR VPWR _4209_/Y sky130_fd_sc_hd__inv_2
XFILLER_73_15 VPWR VGND VPWR VGND sky130_ef_sc_hd__decap_12
XFILLER_56_587 VGND VGND VPWR VPWR sky130_fd_sc_hd__fill_1
XFILLER_22_41 VPWR VGND VPWR VGND sky130_ef_sc_hd__decap_12
XFILLER_22_85 VPWR VGND VPWR VGND sky130_ef_sc_hd__decap_12
XFILLER_3_333 VGND VGND VPWR VPWR sky130_fd_sc_hd__decap_3
XFILLER_105_261 VPWR VGND VPWR VGND sky130_ef_sc_hd__decap_12
XFILLER_78_189 VGND VGND VPWR VPWR sky130_fd_sc_hd__decap_6
XFILLER_19_223 VGND VGND VPWR VPWR sky130_fd_sc_hd__fill_1
XFILLER_47_565 VGND VGND VPWR VPWR sky130_fd_sc_hd__fill_1
XFILLER_74_373 VGND VGND VPWR VPWR sky130_fd_sc_hd__fill_1
XFILLER_74_362 VGND VGND VPWR VPWR sky130_fd_sc_hd__fill_2
XFILLER_62_513 VPWR VGND VPWR VGND sky130_ef_sc_hd__decap_12
XFILLER_62_557 VPWR VGND VPWR VGND sky130_ef_sc_hd__decap_12
XTAP_TAPCELL_ROW_17_424 VGND VPWR sky130_fd_sc_hd__tapvpwrvgnd_1
XTAP_TAPCELL_ROW_45_722 VGND VPWR sky130_fd_sc_hd__tapvpwrvgnd_1
X_2890_ _2889_/B _2889_/C _4537_/Q VGND VGND VPWR VPWR _2891_/B sky130_fd_sc_hd__a21oi_1
X_4560_ _4656_/CLK _4560_/D fanout120/X VGND VGND VPWR VPWR _4560_/Q sky130_fd_sc_hd__dfrtp_1
XFILLER_8_65 VPWR VGND VPWR VGND sky130_ef_sc_hd__decap_12
X_4491_ _4527_/CLK _4491_/D fanout129/X VGND VGND VPWR VPWR _4491_/Q sky130_fd_sc_hd__dfrtp_2
X_3511_ _3509_/Y _3511_/B VGND VGND VPWR VPWR _3511_/Y sky130_fd_sc_hd__nand2b_1
X_3442_ _3442_/A _3525_/A VGND VGND VPWR VPWR _3443_/B sky130_fd_sc_hd__xor2_1
X_3373_ _3373_/A _3373_/B VGND VGND VPWR VPWR _3376_/A sky130_fd_sc_hd__xnor2_1
X_2324_ _2431_/A _2324_/B _4770_/Q VGND VGND VPWR VPWR _2324_/Y sky130_fd_sc_hd__nor3b_1
X_2255_ _4364_/Q _2245_/Y _2256_/B hold135/X VGND VGND VPWR VPWR _4367_/D sky130_fd_sc_hd__a22o_1
X_2186_ _4447_/Q VGND VGND VPWR VPWR _2451_/A sky130_fd_sc_hd__inv_2
XFILLER_65_362 VGND VGND VPWR VPWR sky130_fd_sc_hd__decap_8
XFILLER_38_587 VGND VGND VPWR VPWR sky130_fd_sc_hd__fill_1
XFILLER_53_502 VGND VGND VPWR VPWR sky130_fd_sc_hd__fill_2
XFILLER_92_170 VGND VGND VPWR VPWR sky130_fd_sc_hd__fill_1
XFILLER_80_321 VGND VGND VPWR VPWR sky130_fd_sc_hd__decap_4
XFILLER_53_557 VGND VGND VPWR VPWR sky130_fd_sc_hd__decap_3
X_4758_ _4758_/CLK _4758_/D fanout137/X VGND VGND VPWR VPWR _4758_/Q sky130_fd_sc_hd__dfrtp_1
X_4689_ _4693_/CLK _4689_/D fanout156/X VGND VGND VPWR VPWR _4689_/Q sky130_fd_sc_hd__dfrtp_1
X_3709_ _3732_/C _3709_/B VGND VGND VPWR VPWR _3710_/B sky130_fd_sc_hd__xnor2_1
XTAP_TAPCELL_ROW_95_1278 VGND VPWR sky130_fd_sc_hd__tapvpwrvgnd_1
XFILLER_68_15 VPWR VGND VPWR VGND sky130_ef_sc_hd__decap_12
XFILLER_88_421 VPWR VGND VPWR VGND sky130_ef_sc_hd__decap_12
XFILLER_102_253 VPWR VGND VPWR VGND sky130_ef_sc_hd__decap_12
XFILLER_44_546 VGND VGND VPWR VPWR sky130_fd_sc_hd__fill_2
XFILLER_56_384 VGND VGND VPWR VPWR sky130_fd_sc_hd__decap_3
XFILLER_44_568 VGND VGND VPWR VPWR sky130_fd_sc_hd__decap_6
XTAP_TAPCELL_ROW_104_1374 VGND VPWR sky130_fd_sc_hd__tapvpwrvgnd_1
XFILLER_12_421 VGND VGND VPWR VPWR sky130_fd_sc_hd__fill_1
XFILLER_33_51 VGND VGND VPWR VPWR sky130_fd_sc_hd__decap_4
XFILLER_8_436 VGND VGND VPWR VPWR sky130_fd_sc_hd__fill_1
XTAP_TAPCELL_ROW_22_471 VGND VPWR sky130_fd_sc_hd__tapvpwrvgnd_1
XTAP_TAPCELL_ROW_50_780 VGND VPWR sky130_fd_sc_hd__tapvpwrvgnd_1
XFILLER_106_581 VGND VGND VPWR VPWR sky130_fd_sc_hd__decap_6
XFILLER_79_432 VPWR VGND VPWR VGND sky130_ef_sc_hd__decap_12
XTAP_TAPCELL_ROW_72_1020 VGND VPWR sky130_fd_sc_hd__tapvpwrvgnd_1
XFILLER_94_413 VGND VGND VPWR VPWR sky130_fd_sc_hd__decap_6
Xhold3 hold3/A VGND VGND VPWR VPWR hold3/X sky130_fd_sc_hd__dlygate4sd3_1
XFILLER_94_457 VPWR VGND VPWR VGND sky130_ef_sc_hd__decap_12
XFILLER_35_546 VGND VGND VPWR VPWR sky130_fd_sc_hd__fill_1
X_3991_ _3972_/Y _3978_/B _3989_/Y _3845_/A VGND VGND VPWR VPWR _3991_/X sky130_fd_sc_hd__a31o_1
XFILLER_62_365 VGND VGND VPWR VPWR sky130_fd_sc_hd__decap_4
XFILLER_95_3 VPWR VGND VPWR VGND sky130_ef_sc_hd__decap_12
X_2942_ _4535_/Q _3791_/A VGND VGND VPWR VPWR _2944_/B sky130_fd_sc_hd__or2_1
XFILLER_15_281 VGND VGND VPWR VPWR sky130_fd_sc_hd__fill_1
XFILLER_30_240 VGND VGND VPWR VPWR sky130_fd_sc_hd__decap_3
X_2873_ _2916_/A _2873_/B VGND VGND VPWR VPWR _2874_/B sky130_fd_sc_hd__xnor2_1
X_4612_ _4676_/CLK _4612_/D fanout138/X VGND VGND VPWR VPWR _4612_/Q sky130_fd_sc_hd__dfrtp_1
X_4543_ _4547_/CLK _4543_/D fanout170/X VGND VGND VPWR VPWR _4543_/Q sky130_fd_sc_hd__dfrtp_4
XFILLER_7_480 VGND VGND VPWR VPWR sky130_fd_sc_hd__decap_3
X_4474_ _4715_/CLK _4474_/D fanout172/X VGND VGND VPWR VPWR _4474_/Q sky130_fd_sc_hd__dfrtp_2
Xstream_cipher_179 VGND VGND VPWR VPWR stream_cipher_179/HI uio_oe[7] sky130_fd_sc_hd__conb_1
X_3425_ _4529_/Q _3425_/B VGND VGND VPWR VPWR _3427_/A sky130_fd_sc_hd__xor2_1
X_3356_ _3355_/A _3355_/B _3347_/X VGND VGND VPWR VPWR _3357_/C sky130_fd_sc_hd__o21bai_1
XFILLER_97_273 VGND VGND VPWR VPWR sky130_fd_sc_hd__decap_6
XFILLER_85_413 VGND VGND VPWR VPWR sky130_fd_sc_hd__decap_4
X_3287_ _3287_/A _3287_/B VGND VGND VPWR VPWR _3287_/X sky130_fd_sc_hd__or2_1
X_2307_ _4699_/Q _2478_/A _2313_/A _2306_/X VGND VGND VPWR VPWR _2311_/A sky130_fd_sc_hd__a211o_1
XFILLER_38_29 VPWR VGND VPWR VGND sky130_ef_sc_hd__decap_12
X_2238_ hold58/A _4364_/Q VGND VGND VPWR VPWR _2238_/Y sky130_fd_sc_hd__nor2_1
XFILLER_38_373 VGND VGND VPWR VPWR sky130_fd_sc_hd__decap_3
XFILLER_26_546 VGND VGND VPWR VPWR sky130_fd_sc_hd__fill_2
XFILLER_26_568 VGND VGND VPWR VPWR sky130_fd_sc_hd__fill_2
XFILLER_41_549 VGND VGND VPWR VPWR sky130_fd_sc_hd__fill_2
XFILLER_80_195 VGND VGND VPWR VPWR sky130_fd_sc_hd__fill_1
XFILLER_70_27 VGND VGND VPWR VPWR sky130_fd_sc_hd__fill_1
XFILLER_21_240 VPWR VGND VPWR VGND sky130_ef_sc_hd__decap_12
XFILLER_5_428 VGND VGND VPWR VPWR sky130_fd_sc_hd__decap_8
XFILLER_107_389 VGND VGND VPWR VPWR sky130_fd_sc_hd__decap_3
XFILLER_79_69 VPWR VGND VPWR VGND sky130_ef_sc_hd__decap_12
XFILLER_0_133 VGND VGND VPWR VPWR sky130_fd_sc_hd__decap_6
XFILLER_103_573 VPWR VGND VPWR VGND sky130_ef_sc_hd__decap_12
XFILLER_95_57 VPWR VGND VPWR VGND sky130_ef_sc_hd__decap_12
XFILLER_0_177 VGND VGND VPWR VPWR sky130_fd_sc_hd__fill_1
XFILLER_0_166 VGND VGND VPWR VPWR sky130_fd_sc_hd__fill_2
XFILLER_91_405 VPWR VGND VPWR VGND sky130_ef_sc_hd__decap_12
XFILLER_29_351 VPWR VGND VPWR VGND sky130_ef_sc_hd__decap_12
XTAP_TAPCELL_ROW_106_1403 VGND VPWR sky130_fd_sc_hd__tapvpwrvgnd_1
XFILLER_91_449 VPWR VGND VPWR VGND sky130_ef_sc_hd__decap_12
XFILLER_44_321 VGND VGND VPWR VPWR sky130_fd_sc_hd__decap_4
XFILLER_17_557 VGND VGND VPWR VPWR sky130_fd_sc_hd__decap_3
XTAP_TAPCELL_ROW_27_530 VGND VPWR sky130_fd_sc_hd__tapvpwrvgnd_1
XFILLER_32_505 VGND VGND VPWR VPWR sky130_fd_sc_hd__decap_6
XFILLER_44_365 VPWR VGND VPWR VGND sky130_ef_sc_hd__decap_12
XFILLER_32_516 VGND VGND VPWR VPWR sky130_fd_sc_hd__decap_4
XFILLER_44_83 VGND VGND VPWR VPWR sky130_fd_sc_hd__fill_1
XFILLER_40_560 VGND VGND VPWR VPWR sky130_fd_sc_hd__fill_1
XFILLER_8_277 VPWR VGND VPWR VGND sky130_ef_sc_hd__decap_12
XFILLER_99_505 VPWR VGND VPWR VGND sky130_ef_sc_hd__decap_12
XFILLER_5_55 VGND VGND VPWR VPWR sky130_fd_sc_hd__fill_1
X_3210_ _4518_/Q _3979_/B2 _3922_/B _3978_/A VGND VGND VPWR VPWR _4518_/D sky130_fd_sc_hd__a22o_1
X_4190_ _4695_/Q _4194_/C VGND VGND VPWR VPWR _4190_/Y sky130_fd_sc_hd__nand2_1
X_3141_ _4547_/Q _3141_/B _3141_/C VGND VGND VPWR VPWR _3142_/A sky130_fd_sc_hd__nand3_1
XFILLER_10_3 VPWR VGND VPWR VGND sky130_ef_sc_hd__decap_12
XFILLER_94_265 VPWR VGND VPWR VGND sky130_ef_sc_hd__decap_12
X_3072_ _3072_/A _3072_/B VGND VGND VPWR VPWR _3074_/B sky130_fd_sc_hd__xnor2_2
XPHY_EDGE_ROW_19_Left_127 VGND VGND VPWR VPWR sky130_fd_sc_hd__decap_3
XFILLER_35_332 VGND VGND VPWR VPWR sky130_fd_sc_hd__decap_4
XFILLER_23_505 VGND VGND VPWR VPWR sky130_fd_sc_hd__decap_8
XTAP_TAPCELL_ROW_81_1119 VGND VPWR sky130_fd_sc_hd__tapvpwrvgnd_1
X_3974_ _3974_/A _3974_/B VGND VGND VPWR VPWR _3974_/X sky130_fd_sc_hd__or2_1
X_2925_ _2925_/A _2925_/B VGND VGND VPWR VPWR _2927_/B sky130_fd_sc_hd__xnor2_1
XPHY_EDGE_ROW_28_Left_136 VGND VGND VPWR VPWR sky130_fd_sc_hd__decap_3
XTAP_TAPCELL_ROW_33_599 VGND VPWR sky130_fd_sc_hd__tapvpwrvgnd_1
X_2856_ _2834_/B _2834_/C _2855_/B _2834_/A VGND VGND VPWR VPWR _2878_/C sky130_fd_sc_hd__a211o_2
Xhold211 _4400_/Q VGND VGND VPWR VPWR hold211/X sky130_fd_sc_hd__dlygate4sd3_1
X_2787_ _4746_/Q _2810_/B _2807_/A _2767_/B VGND VGND VPWR VPWR _2796_/A sky130_fd_sc_hd__o2bb2a_1
Xhold200 _4424_/Q VGND VGND VPWR VPWR hold200/X sky130_fd_sc_hd__dlygate4sd3_1
Xhold233 _4399_/Q VGND VGND VPWR VPWR hold233/X sky130_fd_sc_hd__dlygate4sd3_1
X_4526_ _4734_/CLK _4526_/D fanout146/X VGND VGND VPWR VPWR _4526_/Q sky130_fd_sc_hd__dfrtp_4
Xhold244 _4447_/Q VGND VGND VPWR VPWR hold244/X sky130_fd_sc_hd__dlygate4sd3_1
Xhold222 _4407_/Q VGND VGND VPWR VPWR hold222/X sky130_fd_sc_hd__dlygate4sd3_1
XTAP_TAPCELL_ROW_92_1248 VGND VPWR sky130_fd_sc_hd__tapvpwrvgnd_1
Xhold255 _4453_/Q VGND VGND VPWR VPWR hold255/X sky130_fd_sc_hd__dlygate4sd3_1
X_4457_ _4699_/CLK _4457_/D fanout159/X VGND VGND VPWR VPWR _4457_/Q sky130_fd_sc_hd__dfrtp_1
Xhold266 _4710_/Q VGND VGND VPWR VPWR hold266/X sky130_fd_sc_hd__dlygate4sd3_1
Xhold277 _4474_/Q VGND VGND VPWR VPWR hold277/X sky130_fd_sc_hd__dlygate4sd3_1
X_3408_ _3554_/B2 _3406_/X _3407_/Y _3470_/B2 _4528_/Q VGND VGND VPWR VPWR _4528_/D
+ sky130_fd_sc_hd__a32o_1
XFILLER_49_39 VPWR VGND VPWR VGND sky130_ef_sc_hd__decap_12
Xhold299 _4754_/Q VGND VGND VPWR VPWR hold299/X sky130_fd_sc_hd__dlygate4sd3_1
Xhold288 _4397_/Q VGND VGND VPWR VPWR hold288/X sky130_fd_sc_hd__dlygate4sd3_1
X_4388_ _4726_/CLK _4388_/D fanout153/X VGND VGND VPWR VPWR hold17/A sky130_fd_sc_hd__dfrtp_1
X_3339_ _4740_/Q _3339_/B VGND VGND VPWR VPWR _3340_/B sky130_fd_sc_hd__and2_1
XPHY_EDGE_ROW_37_Left_145 VGND VGND VPWR VPWR sky130_fd_sc_hd__decap_3
XFILLER_100_587 VGND VGND VPWR VPWR sky130_fd_sc_hd__fill_1
XFILLER_73_416 VGND VGND VPWR VPWR sky130_fd_sc_hd__decap_8
XTAP_TAPCELL_ROW_69_986 VGND VPWR sky130_fd_sc_hd__tapvpwrvgnd_1
XFILLER_65_27 VPWR VGND VPWR VGND sky130_ef_sc_hd__decap_12
XFILLER_73_449 VPWR VGND VPWR VGND sky130_ef_sc_hd__decap_12
XFILLER_81_15 VPWR VGND VPWR VGND sky130_ef_sc_hd__decap_12
XFILLER_14_516 VGND VGND VPWR VPWR sky130_fd_sc_hd__fill_1
XTAP_TAPCELL_ROW_24_500 VGND VPWR sky130_fd_sc_hd__tapvpwrvgnd_1
XFILLER_53_162 VGND VGND VPWR VPWR sky130_fd_sc_hd__decap_6
XTAP_TAPCELL_ROW_101_1344 VGND VPWR sky130_fd_sc_hd__tapvpwrvgnd_1
XFILLER_14_53 VPWR VGND VPWR VGND sky130_ef_sc_hd__decap_12
XPHY_EDGE_ROW_46_Left_154 VGND VGND VPWR VPWR sky130_fd_sc_hd__decap_3
XFILLER_14_97 VPWR VGND VPWR VGND sky130_ef_sc_hd__decap_12
XFILLER_5_225 VGND VGND VPWR VPWR sky130_fd_sc_hd__decap_8
XFILLER_30_41 VPWR VGND VPWR VGND sky130_ef_sc_hd__decap_12
XFILLER_107_197 VPWR VGND VPWR VGND sky130_ef_sc_hd__decap_12
XFILLER_30_85 VGND VGND VPWR VPWR sky130_fd_sc_hd__decap_6
XPHY_EDGE_ROW_55_Left_163 VGND VGND VPWR VPWR sky130_fd_sc_hd__decap_3
XFILLER_49_424 VGND VGND VPWR VPWR sky130_fd_sc_hd__fill_1
XFILLER_49_457 VGND VGND VPWR VPWR sky130_fd_sc_hd__decap_6
XFILLER_76_276 VGND VGND VPWR VPWR sky130_fd_sc_hd__decap_3
XPHY_EDGE_ROW_101_Right_101 VGND VGND VPWR VPWR sky130_fd_sc_hd__decap_3
XFILLER_76_298 VGND VGND VPWR VPWR sky130_fd_sc_hd__decap_4
Xclkbuf_leaf_56_clk clkload0/A VGND VGND VPWR VPWR _4737_/CLK sky130_fd_sc_hd__clkbuf_8
XTAP_TAPCELL_ROW_4_280 VGND VPWR sky130_fd_sc_hd__tapvpwrvgnd_1
XFILLER_91_279 VGND VGND VPWR VPWR sky130_fd_sc_hd__fill_1
XPHY_EDGE_ROW_64_Left_172 VGND VGND VPWR VPWR sky130_fd_sc_hd__decap_3
X_2710_ _2710_/A _2710_/B VGND VGND VPWR VPWR _2711_/C sky130_fd_sc_hd__or2_1
XFILLER_9_564 VGND VGND VPWR VPWR sky130_fd_sc_hd__fill_1
XTAP_TAPCELL_ROW_30_558 VGND VPWR sky130_fd_sc_hd__tapvpwrvgnd_1
X_3690_ _4539_/Q _3662_/B _3688_/X VGND VGND VPWR VPWR _3690_/Y sky130_fd_sc_hd__o21ai_1
X_2641_ _4494_/Q _2642_/B VGND VGND VPWR VPWR _2641_/X sky130_fd_sc_hd__and2_1
X_2572_ _3382_/A _4522_/Q VGND VGND VPWR VPWR _2573_/B sky130_fd_sc_hd__or2_1
XFILLER_58_3 VPWR VGND VPWR VGND sky130_ef_sc_hd__decap_12
XFILLER_99_335 VGND VGND VPWR VPWR sky130_fd_sc_hd__fill_1
XTAP_TAPCELL_ROW_78_1092 VGND VPWR sky130_fd_sc_hd__tapvpwrvgnd_1
XPHY_EDGE_ROW_73_Left_181 VGND VGND VPWR VPWR sky130_fd_sc_hd__decap_3
X_4311_ _4318_/A _4311_/B VGND VGND VPWR VPWR _4311_/Y sky130_fd_sc_hd__nor2_1
X_4242_ _4265_/B _4239_/X _4241_/Y _4262_/A hold252/X VGND VGND VPWR VPWR _4709_/D
+ sky130_fd_sc_hd__a32o_1
XFILLER_101_329 VGND VGND VPWR VPWR sky130_fd_sc_hd__decap_6
XFILLER_95_541 VPWR VGND VPWR VGND sky130_ef_sc_hd__decap_12
X_4173_ _4690_/Q _4176_/C VGND VGND VPWR VPWR _4173_/Y sky130_fd_sc_hd__nand2_1
XFILLER_95_585 VPWR VGND VPWR VGND sky130_ef_sc_hd__decap_12
X_3124_ _3124_/A _3124_/B VGND VGND VPWR VPWR _3126_/B sky130_fd_sc_hd__xnor2_1
X_3055_ _3104_/B _3055_/B VGND VGND VPWR VPWR _3858_/A sky130_fd_sc_hd__xnor2_4
XFILLER_55_449 VGND VGND VPWR VPWR sky130_fd_sc_hd__decap_4
XFILLER_82_257 VPWR VGND VPWR VGND sky130_ef_sc_hd__decap_12
XTAP_TAPCELL_ROW_66_956 VGND VPWR sky130_fd_sc_hd__tapvpwrvgnd_1
Xclkbuf_leaf_47_clk clkload4/A VGND VGND VPWR VPWR _4533_/CLK sky130_fd_sc_hd__clkbuf_8
XTAP_TAPCELL_ROW_38_647 VGND VPWR sky130_fd_sc_hd__tapvpwrvgnd_1
XPHY_EDGE_ROW_82_Left_190 VGND VGND VPWR VPWR sky130_fd_sc_hd__decap_3
X_3957_ _3978_/A _3955_/Y _3956_/X _3979_/B2 _4551_/Q VGND VGND VPWR VPWR _4551_/D
+ sky130_fd_sc_hd__a32o_1
X_2908_ _2908_/A VGND VGND VPWR VPWR _2908_/Y sky130_fd_sc_hd__inv_2
X_3888_ _3889_/C VGND VGND VPWR VPWR _3931_/A sky130_fd_sc_hd__inv_2
X_2839_ _4749_/Q _2839_/B VGND VGND VPWR VPWR _2840_/B sky130_fd_sc_hd__nand2_1
X_4509_ _4509_/CLK _4509_/D fanout143/X VGND VGND VPWR VPWR _4509_/Q sky130_fd_sc_hd__dfrtp_2
XFILLER_104_189 VGND VGND VPWR VPWR sky130_fd_sc_hd__decap_6
XFILLER_76_15 VPWR VGND VPWR VGND sky130_ef_sc_hd__decap_12
XFILLER_19_608 VGND VGND VPWR VPWR sky130_fd_sc_hd__decap_3
XFILLER_58_298 VGND VGND VPWR VPWR sky130_fd_sc_hd__fill_2
Xclkbuf_leaf_38_clk _4459_/CLK VGND VGND VPWR VPWR _4724_/CLK sky130_fd_sc_hd__clkbuf_8
XFILLER_26_195 VGND VGND VPWR VPWR sky130_fd_sc_hd__fill_1
XFILLER_41_110 VGND VGND VPWR VPWR sky130_fd_sc_hd__fill_2
XFILLER_10_541 VGND VGND VPWR VPWR sky130_fd_sc_hd__fill_2
XFILLER_10_530 VGND VGND VPWR VPWR sky130_fd_sc_hd__fill_2
XFILLER_10_563 VGND VGND VPWR VPWR sky130_fd_sc_hd__decap_8
XFILLER_6_512 VGND VGND VPWR VPWR sky130_fd_sc_hd__decap_4
XFILLER_41_51 VGND VGND VPWR VPWR sky130_fd_sc_hd__decap_4
XFILLER_6_589 VGND VGND VPWR VPWR sky130_fd_sc_hd__decap_6
XFILLER_89_390 VGND VGND VPWR VPWR sky130_fd_sc_hd__fill_2
XFILLER_77_541 VPWR VGND VPWR VGND sky130_ef_sc_hd__decap_12
XFILLER_92_533 VPWR VGND VPWR VGND sky130_ef_sc_hd__decap_12
XFILLER_77_585 VPWR VGND VPWR VGND sky130_ef_sc_hd__decap_12
XFILLER_37_449 VGND VGND VPWR VPWR sky130_fd_sc_hd__fill_2
Xclkbuf_leaf_29_clk clkload6/A VGND VGND VPWR VPWR _4538_/CLK sky130_fd_sc_hd__clkbuf_8
XTAP_TAPCELL_ROW_63_926 VGND VPWR sky130_fd_sc_hd__tapvpwrvgnd_1
XTAP_TAPCELL_ROW_35_617 VGND VPWR sky130_fd_sc_hd__tapvpwrvgnd_1
X_3811_ _3790_/Y _3793_/B _3789_/Y VGND VGND VPWR VPWR _3812_/B sky130_fd_sc_hd__o21a_1
XFILLER_20_338 VGND VGND VPWR VPWR sky130_fd_sc_hd__decap_4
X_3742_ _3742_/A _3742_/B VGND VGND VPWR VPWR _3744_/B sky130_fd_sc_hd__xnor2_1
XTAP_TAPCELL_ROW_15_396 VGND VPWR sky130_fd_sc_hd__tapvpwrvgnd_1
X_3673_ _3651_/B _3672_/X _3656_/Y VGND VGND VPWR VPWR _3674_/B sky130_fd_sc_hd__a21o_1
X_2624_ _3417_/A VGND VGND VPWR VPWR _2624_/Y sky130_fd_sc_hd__inv_2
XTAP_TAPCELL_ROW_7_309 VGND VPWR sky130_fd_sc_hd__tapvpwrvgnd_1
X_2555_ _4479_/Q _2555_/B VGND VGND VPWR VPWR _2555_/X sky130_fd_sc_hd__or2_1
X_2486_ _2486_/A1 _2488_/B _2485_/X _2486_/B1 _4457_/Q VGND VGND VPWR VPWR _4457_/D
+ sky130_fd_sc_hd__a32o_1
XFILLER_101_137 VPWR VGND VPWR VGND sky130_ef_sc_hd__decap_12
XFILLER_87_349 VPWR VGND VPWR VGND sky130_ef_sc_hd__decap_12
X_4225_ _4225_/A _4225_/B VGND VGND VPWR VPWR _4229_/B sky130_fd_sc_hd__nor2_1
X_4156_ _4149_/B _4028_/X _4095_/Y _4149_/Y hold74/X VGND VGND VPWR VPWR _4683_/D
+ sky130_fd_sc_hd__a32o_1
XFILLER_95_393 VPWR VGND VPWR VGND sky130_ef_sc_hd__decap_12
X_3107_ _4513_/Q _3098_/B _3100_/A VGND VGND VPWR VPWR _3107_/X sky130_fd_sc_hd__a21bo_1
XFILLER_46_29 VPWR VGND VPWR VGND sky130_ef_sc_hd__decap_12
X_4087_ hold292/X _4729_/Q _4093_/S VGND VGND VPWR VPWR _4622_/D sky130_fd_sc_hd__mux2_1
XFILLER_70_205 VGND VGND VPWR VPWR sky130_fd_sc_hd__fill_2
X_3038_ _4757_/Q _3038_/B VGND VGND VPWR VPWR _3039_/B sky130_fd_sc_hd__nand2_1
XFILLER_24_600 VGND VGND VPWR VPWR sky130_fd_sc_hd__decap_4
XFILLER_23_121 VGND VGND VPWR VPWR sky130_fd_sc_hd__fill_2
XFILLER_23_143 VGND VGND VPWR VPWR sky130_fd_sc_hd__decap_3
XFILLER_3_559 VGND VGND VPWR VPWR sky130_fd_sc_hd__fill_1
XFILLER_78_305 VGND VGND VPWR VPWR sky130_fd_sc_hd__decap_3
XFILLER_87_69 VPWR VGND VPWR VGND sky130_ef_sc_hd__decap_12
XFILLER_59_541 VPWR VGND VPWR VGND sky130_ef_sc_hd__decap_12
XFILLER_86_382 VGND VGND VPWR VPWR sky130_fd_sc_hd__fill_2
XFILLER_74_533 VPWR VGND VPWR VGND sky130_ef_sc_hd__decap_12
XFILLER_59_585 VPWR VGND VPWR VGND sky130_ef_sc_hd__decap_12
XFILLER_19_449 VGND VGND VPWR VPWR sky130_fd_sc_hd__fill_1
XFILLER_61_216 VGND VGND VPWR VPWR sky130_fd_sc_hd__decap_8
XFILLER_61_238 VGND VGND VPWR VPWR sky130_fd_sc_hd__fill_2
XFILLER_27_493 VGND VGND VPWR VPWR sky130_fd_sc_hd__decap_8
XFILLER_42_463 VGND VGND VPWR VPWR sky130_fd_sc_hd__fill_1
XFILLER_52_83 VGND VGND VPWR VPWR sky130_fd_sc_hd__fill_1
XTAP_TAPCELL_ROW_12_366 VGND VPWR sky130_fd_sc_hd__tapvpwrvgnd_1
XTAP_TAPCELL_ROW_40_675 VGND VPWR sky130_fd_sc_hd__tapvpwrvgnd_1
XTAP_TAPCELL_ROW_75_1062 VGND VPWR sky130_fd_sc_hd__tapvpwrvgnd_1
X_2340_ _2340_/A _4718_/D VGND VGND VPWR VPWR _4727_/D sky130_fd_sc_hd__and2_1
X_2271_ _4467_/Q _2271_/B _4711_/Q VGND VGND VPWR VPWR _2271_/X sky130_fd_sc_hd__or3b_1
XFILLER_77_91 VGND VGND VPWR VPWR sky130_fd_sc_hd__decap_4
X_4010_ _4131_/D _4140_/B _4131_/B _4363_/Q VGND VGND VPWR VPWR _4012_/B sky130_fd_sc_hd__o31a_1
XFILLER_77_393 VPWR VGND VPWR VGND sky130_ef_sc_hd__decap_12
XFILLER_37_257 VGND VGND VPWR VPWR sky130_fd_sc_hd__fill_1
XFILLER_92_363 VGND VGND VPWR VPWR sky130_fd_sc_hd__fill_1
XFILLER_80_525 VGND VGND VPWR VPWR sky130_fd_sc_hd__decap_6
XFILLER_37_268 VPWR VGND VPWR VGND sky130_ef_sc_hd__decap_12
XTAP_TAPCELL_ROW_48_764 VGND VPWR sky130_fd_sc_hd__tapvpwrvgnd_1
XTAP_TAPCELL_ROW_86_1180 VGND VPWR sky130_fd_sc_hd__tapvpwrvgnd_1
XFILLER_52_249 VGND VGND VPWR VPWR sky130_fd_sc_hd__decap_3
XFILLER_80_569 VPWR VGND VPWR VGND sky130_ef_sc_hd__decap_12
X_3725_ _4641_/Q _4577_/Q _4673_/Q _4609_/Q _3915_/S0 _3915_/S1 VGND VGND VPWR VPWR
+ _3727_/B sky130_fd_sc_hd__mux4_1
Xclkbuf_leaf_9_clk clkload2/A VGND VGND VPWR VPWR _4671_/CLK sky130_fd_sc_hd__clkbuf_8
X_3656_ _3657_/A _3657_/B VGND VGND VPWR VPWR _3656_/Y sky130_fd_sc_hd__nor2_1
X_2607_ _2595_/A _2594_/B _2592_/X VGND VGND VPWR VPWR _2618_/A sky130_fd_sc_hd__a21oi_1
X_3587_ _3538_/B _3585_/Y _3586_/Y VGND VGND VPWR VPWR _3588_/B sky130_fd_sc_hd__o21a_1
XFILLER_88_625 VPWR VGND VPWR VGND sky130_ef_sc_hd__decap_12
X_2538_ _4474_/Q _4473_/Q VGND VGND VPWR VPWR _2538_/Y sky130_fd_sc_hd__nand2_1
XFILLER_102_413 VGND VGND VPWR VPWR sky130_fd_sc_hd__decap_6
XFILLER_87_113 VGND VGND VPWR VPWR sky130_fd_sc_hd__decap_4
XFILLER_102_457 VPWR VGND VPWR VGND sky130_ef_sc_hd__decap_12
XTAP_TAPCELL_ROW_89_1209 VGND VPWR sky130_fd_sc_hd__tapvpwrvgnd_1
XFILLER_87_157 VGND VGND VPWR VPWR sky130_fd_sc_hd__decap_3
X_2469_ _4451_/Q _4450_/Q _2458_/A _4452_/Q VGND VGND VPWR VPWR _2469_/X sky130_fd_sc_hd__a31o_1
X_4208_ _4700_/Q _4208_/B VGND VGND VPWR VPWR _4212_/B sky130_fd_sc_hd__and2_1
XFILLER_57_39 VPWR VGND VPWR VGND sky130_ef_sc_hd__decap_12
X_4139_ hold93/X _4139_/A1 _4139_/S VGND VGND VPWR VPWR _4668_/D sky130_fd_sc_hd__mux2_1
XFILLER_56_533 VPWR VGND VPWR VGND sky130_ef_sc_hd__decap_12
XFILLER_83_385 VGND VGND VPWR VPWR sky130_fd_sc_hd__fill_2
XFILLER_73_27 VPWR VGND VPWR VGND sky130_ef_sc_hd__decap_12
XFILLER_16_419 VGND VGND VPWR VPWR sky130_fd_sc_hd__fill_1
XFILLER_36_290 VGND VGND VPWR VPWR sky130_fd_sc_hd__decap_6
XFILLER_22_53 VPWR VGND VPWR VGND sky130_ef_sc_hd__decap_12
XFILLER_22_97 VGND VGND VPWR VPWR sky130_fd_sc_hd__decap_6
XFILLER_105_273 VGND VGND VPWR VPWR sky130_fd_sc_hd__decap_6
XFILLER_93_105 VGND VGND VPWR VPWR sky130_fd_sc_hd__decap_6
Xfanout170 fanout171/X VGND VGND VPWR VPWR fanout170/X sky130_fd_sc_hd__clkbuf_4
XFILLER_59_393 VPWR VGND VPWR VGND sky130_ef_sc_hd__decap_12
XFILLER_62_525 VGND VGND VPWR VPWR sky130_fd_sc_hd__decap_6
XFILLER_34_216 VGND VGND VPWR VPWR sky130_fd_sc_hd__fill_1
XTAP_TAPCELL_ROW_17_414 VGND VPWR sky130_fd_sc_hd__tapvpwrvgnd_1
XFILLER_34_238 VGND VGND VPWR VPWR sky130_fd_sc_hd__fill_1
XTAP_TAPCELL_ROW_45_723 VGND VPWR sky130_fd_sc_hd__tapvpwrvgnd_1
XFILLER_62_569 VPWR VGND VPWR VGND sky130_ef_sc_hd__decap_12
Xclkbuf_3_4__f_clk clkbuf_0_clk/X VGND VGND VPWR VPWR clkload4/A sky130_fd_sc_hd__clkbuf_16
XFILLER_30_477 VPWR VGND VPWR VGND sky130_ef_sc_hd__decap_12
XFILLER_8_77 VGND VGND VPWR VPWR sky130_fd_sc_hd__decap_6
X_3510_ _4533_/Q _3510_/B VGND VGND VPWR VPWR _3511_/B sky130_fd_sc_hd__nand2_1
X_4490_ _4527_/CLK _4490_/D fanout129/X VGND VGND VPWR VPWR _4490_/Q sky130_fd_sc_hd__dfrtp_1
X_3441_ _3441_/A _3441_/B VGND VGND VPWR VPWR _3525_/A sky130_fd_sc_hd__nor2_1
X_3372_ _3373_/A _3373_/B VGND VGND VPWR VPWR _3394_/A sky130_fd_sc_hd__nand2b_1
XFILLER_40_3 VPWR VGND VPWR VGND sky130_ef_sc_hd__decap_12
XFILLER_69_113 VGND VGND VPWR VPWR sky130_fd_sc_hd__decap_6
X_2323_ hold58/X _2245_/Y _2254_/Y _4770_/Q VGND VGND VPWR VPWR _4369_/D sky130_fd_sc_hd__a22o_1
XFILLER_85_617 VPWR VGND VPWR VGND sky130_ef_sc_hd__decap_12
X_2254_ _2431_/A _2354_/A VGND VGND VPWR VPWR _2254_/Y sky130_fd_sc_hd__nor2_1
XFILLER_57_319 VGND VGND VPWR VPWR sky130_fd_sc_hd__fill_1
XFILLER_65_341 VGND VGND VPWR VPWR sky130_fd_sc_hd__fill_1
X_2185_ _4448_/Q VGND VGND VPWR VPWR _2185_/Y sky130_fd_sc_hd__inv_2
XFILLER_65_385 VGND VGND VPWR VPWR sky130_fd_sc_hd__fill_2
XFILLER_33_293 VGND VGND VPWR VPWR sky130_fd_sc_hd__fill_2
XFILLER_21_466 VGND VGND VPWR VPWR sky130_fd_sc_hd__decap_3
X_4757_ _4757_/CLK _4757_/D fanout137/X VGND VGND VPWR VPWR _4757_/Q sky130_fd_sc_hd__dfrtp_1
XFILLER_107_505 VPWR VGND VPWR VGND sky130_ef_sc_hd__decap_12
XFILLER_4_109 VPWR VGND VPWR VGND sky130_ef_sc_hd__decap_12
X_4688_ _4693_/CLK _4688_/D fanout156/X VGND VGND VPWR VPWR _4688_/Q sky130_fd_sc_hd__dfrtp_2
X_3708_ _3708_/A _3720_/C VGND VGND VPWR VPWR _3709_/B sky130_fd_sc_hd__xnor2_1
XTAP_TAPCELL_ROW_95_1279 VGND VPWR sky130_fd_sc_hd__tapvpwrvgnd_1
X_3639_ _3638_/B _3638_/C _3638_/A VGND VGND VPWR VPWR _3640_/B sky130_fd_sc_hd__o21ai_1
XFILLER_102_221 VPWR VGND VPWR VGND sky130_ef_sc_hd__decap_12
XFILLER_88_433 VPWR VGND VPWR VGND sky130_ef_sc_hd__decap_12
XFILLER_68_27 VGND VGND VPWR VPWR sky130_fd_sc_hd__fill_1
XFILLER_0_304 VGND VGND VPWR VPWR sky130_fd_sc_hd__decap_4
XFILLER_0_337 VPWR VGND VPWR VGND sky130_ef_sc_hd__decap_12
XFILLER_88_477 VPWR VGND VPWR VGND sky130_ef_sc_hd__decap_12
XFILLER_102_265 VPWR VGND VPWR VGND sky130_ef_sc_hd__decap_12
XFILLER_75_105 VGND VGND VPWR VPWR sky130_fd_sc_hd__decap_6
XFILLER_91_609 VGND VGND VPWR VPWR sky130_fd_sc_hd__decap_6
XFILLER_84_15 VPWR VGND VPWR VGND sky130_ef_sc_hd__decap_12
XFILLER_16_238 VGND VGND VPWR VPWR sky130_fd_sc_hd__decap_3
XFILLER_44_525 VGND VGND VPWR VPWR sky130_fd_sc_hd__decap_6
XTAP_TAPCELL_ROW_104_1375 VGND VPWR sky130_fd_sc_hd__tapvpwrvgnd_1
XFILLER_24_271 VGND VGND VPWR VPWR sky130_fd_sc_hd__fill_1
XTAP_TAPCELL_ROW_22_472 VGND VPWR sky130_fd_sc_hd__tapvpwrvgnd_1
XTAP_TAPCELL_ROW_50_781 VGND VPWR sky130_fd_sc_hd__tapvpwrvgnd_1
XTAP_TAPCELL_ROW_72_1021 VGND VPWR sky130_fd_sc_hd__tapvpwrvgnd_1
XFILLER_79_444 VGND VGND VPWR VPWR sky130_fd_sc_hd__decap_4
XFILLER_67_617 VPWR VGND VPWR VGND sky130_ef_sc_hd__decap_12
Xhold4 hold4/A VGND VGND VPWR VPWR hold4/X sky130_fd_sc_hd__dlygate4sd3_1
XFILLER_94_469 VGND VGND VPWR VPWR sky130_fd_sc_hd__decap_6
XTAP_TAPCELL_ROW_58_870 VGND VPWR sky130_fd_sc_hd__tapvpwrvgnd_1
X_3990_ _3972_/Y _3978_/B _3989_/Y VGND VGND VPWR VPWR _3990_/Y sky130_fd_sc_hd__a21oi_1
XFILLER_62_355 VGND VGND VPWR VPWR sky130_fd_sc_hd__decap_8
XFILLER_35_569 VGND VGND VPWR VPWR sky130_fd_sc_hd__decap_3
XTAP_TAPCELL_ROW_83_1150 VGND VPWR sky130_fd_sc_hd__tapvpwrvgnd_1
X_2941_ _2963_/B _2941_/B VGND VGND VPWR VPWR _2950_/A sky130_fd_sc_hd__xnor2_1
XFILLER_88_3 VPWR VGND VPWR VGND sky130_ef_sc_hd__decap_12
X_4611_ _4758_/CLK _4611_/D fanout140/X VGND VGND VPWR VPWR _4611_/Q sky130_fd_sc_hd__dfrtp_1
XFILLER_30_263 VGND VGND VPWR VPWR sky130_fd_sc_hd__decap_8
X_2872_ _2919_/A _2824_/B _2919_/B _2871_/X VGND VGND VPWR VPWR _2873_/B sky130_fd_sc_hd__o31ai_2
X_4542_ _4542_/CLK _4542_/D fanout168/X VGND VGND VPWR VPWR _4542_/Q sky130_fd_sc_hd__dfrtp_4
X_4473_ _4715_/CLK _4473_/D fanout172/X VGND VGND VPWR VPWR _4473_/Q sky130_fd_sc_hd__dfrtp_2
X_3424_ _4529_/Q _3425_/B VGND VGND VPWR VPWR _3424_/X sky130_fd_sc_hd__and2_1
X_3355_ _3355_/A _3355_/B _3347_/X VGND VGND VPWR VPWR _3357_/B sky130_fd_sc_hd__or3b_1
XFILLER_85_403 VGND VGND VPWR VPWR sky130_fd_sc_hd__decap_6
X_3286_ _3281_/Y _3282_/X _3283_/X _3569_/S0 _3280_/Y VGND VGND VPWR VPWR _3286_/X
+ sky130_fd_sc_hd__o221a_1
X_2306_ _4204_/A _4455_/Q _4201_/A _4454_/Q _2312_/C VGND VGND VPWR VPWR _2306_/X
+ sky130_fd_sc_hd__a221o_1
XFILLER_73_609 VGND VGND VPWR VPWR sky130_fd_sc_hd__decap_6
X_2237_ hold224/X _2236_/Y _4371_/D VGND VGND VPWR VPWR _4356_/D sky130_fd_sc_hd__a21o_1
XFILLER_26_514 VGND VGND VPWR VPWR sky130_fd_sc_hd__decap_3
XFILLER_38_363 VGND VGND VPWR VPWR sky130_fd_sc_hd__fill_1
XFILLER_54_29 VPWR VGND VPWR VGND sky130_ef_sc_hd__decap_12
XFILLER_80_141 VGND VGND VPWR VPWR sky130_fd_sc_hd__fill_2
XFILLER_34_580 VGND VGND VPWR VPWR sky130_fd_sc_hd__fill_1
XFILLER_53_377 VPWR VGND VPWR VGND sky130_ef_sc_hd__decap_12
XFILLER_21_252 VGND VGND VPWR VPWR sky130_fd_sc_hd__decap_8
XPHY_EDGE_ROW_17_Right_17 VGND VGND VPWR VPWR sky130_fd_sc_hd__decap_3
XFILLER_79_15 VPWR VGND VPWR VGND sky130_ef_sc_hd__decap_12
XFILLER_103_541 VPWR VGND VPWR VGND sky130_ef_sc_hd__decap_12
XFILLER_103_585 VPWR VGND VPWR VGND sky130_ef_sc_hd__decap_12
XPHY_EDGE_ROW_26_Right_26 VGND VGND VPWR VPWR sky130_fd_sc_hd__decap_3
XFILLER_49_617 VPWR VGND VPWR VGND sky130_ef_sc_hd__decap_12
XFILLER_95_69 VPWR VGND VPWR VGND sky130_ef_sc_hd__decap_12
XFILLER_76_458 VPWR VGND VPWR VGND sky130_ef_sc_hd__decap_12
XFILLER_28_41 VPWR VGND VPWR VGND sky130_ef_sc_hd__decap_12
XFILLER_91_417 VPWR VGND VPWR VGND sky130_ef_sc_hd__decap_12
XFILLER_17_503 VGND VGND VPWR VPWR sky130_fd_sc_hd__fill_1
XFILLER_29_363 VGND VGND VPWR VPWR sky130_fd_sc_hd__decap_4
XTAP_TAPCELL_ROW_27_531 VGND VPWR sky130_fd_sc_hd__tapvpwrvgnd_1
XTAP_TAPCELL_ROW_55_840 VGND VPWR sky130_fd_sc_hd__tapvpwrvgnd_1
XFILLER_32_528 VGND VGND VPWR VPWR sky130_fd_sc_hd__fill_1
XFILLER_44_377 VGND VGND VPWR VPWR sky130_fd_sc_hd__fill_2
XFILLER_44_388 VGND VGND VPWR VPWR sky130_fd_sc_hd__decap_8
XPHY_EDGE_ROW_35_Right_35 VGND VGND VPWR VPWR sky130_fd_sc_hd__decap_3
XFILLER_60_83 VGND VGND VPWR VPWR sky130_fd_sc_hd__fill_1
XFILLER_8_289 VPWR VGND VPWR VGND sky130_ef_sc_hd__decap_12
XFILLER_99_517 VPWR VGND VPWR VGND sky130_ef_sc_hd__decap_12
XFILLER_4_451 VPWR VGND VPWR VGND sky130_ef_sc_hd__decap_12
XFILLER_69_81 VGND VGND VPWR VPWR sky130_fd_sc_hd__decap_6
XPHY_EDGE_ROW_44_Right_44 VGND VGND VPWR VPWR sky130_fd_sc_hd__decap_3
X_3140_ _4543_/Q _4552_/Q VGND VGND VPWR VPWR _3141_/C sky130_fd_sc_hd__nand2_1
XFILLER_94_277 VPWR VGND VPWR VGND sky130_ef_sc_hd__decap_12
XFILLER_82_417 VGND VGND VPWR VPWR sky130_fd_sc_hd__decap_3
XFILLER_67_469 VPWR VGND VPWR VGND sky130_ef_sc_hd__decap_12
X_3071_ _3071_/A _3071_/B VGND VGND VPWR VPWR _3072_/B sky130_fd_sc_hd__xor2_2
XFILLER_55_609 VGND VGND VPWR VPWR sky130_fd_sc_hd__decap_6
XFILLER_75_491 VPWR VGND VPWR VGND sky130_ef_sc_hd__decap_12
XFILLER_62_130 VGND VGND VPWR VPWR sky130_fd_sc_hd__decap_3
X_3973_ _4552_/Q _3973_/B VGND VGND VPWR VPWR _3976_/A sky130_fd_sc_hd__xnor2_2
XFILLER_50_325 VGND VGND VPWR VPWR sky130_fd_sc_hd__fill_1
XPHY_EDGE_ROW_53_Right_53 VGND VGND VPWR VPWR sky130_fd_sc_hd__decap_3
XFILLER_31_561 VPWR VGND VPWR VGND sky130_ef_sc_hd__decap_12
X_2924_ _2924_/A _2924_/B VGND VGND VPWR VPWR _2925_/B sky130_fd_sc_hd__and2_1
XTAP_TAPCELL_ROW_61_898 VGND VPWR sky130_fd_sc_hd__tapvpwrvgnd_1
X_2855_ _2855_/A _2855_/B VGND VGND VPWR VPWR _2878_/B sky130_fd_sc_hd__or2_1
X_4525_ _4734_/CLK _4525_/D fanout146/X VGND VGND VPWR VPWR _4525_/Q sky130_fd_sc_hd__dfrtp_4
X_2786_ _2771_/B _2774_/B _2771_/A VGND VGND VPWR VPWR _2797_/A sky130_fd_sc_hd__a21bo_1
Xhold201 _2409_/X VGND VGND VPWR VPWR _4424_/D sky130_fd_sc_hd__dlygate4sd3_1
Xhold234 _4621_/Q VGND VGND VPWR VPWR hold234/X sky130_fd_sc_hd__dlygate4sd3_1
Xhold223 _2392_/X VGND VGND VPWR VPWR _4407_/D sky130_fd_sc_hd__dlygate4sd3_1
Xhold212 _4488_/Q VGND VGND VPWR VPWR hold212/X sky130_fd_sc_hd__dlygate4sd3_1
XTAP_TAPCELL_ROW_92_1249 VGND VPWR sky130_fd_sc_hd__tapvpwrvgnd_1
XPHY_EDGE_ROW_62_Right_62 VGND VGND VPWR VPWR sky130_fd_sc_hd__decap_3
Xhold278 _4690_/Q VGND VGND VPWR VPWR hold278/X sky130_fd_sc_hd__dlygate4sd3_1
X_4456_ _4699_/CLK _4456_/D fanout159/X VGND VGND VPWR VPWR _4456_/Q sky130_fd_sc_hd__dfrtp_1
Xhold267 _4459_/Q VGND VGND VPWR VPWR hold267/X sky130_fd_sc_hd__dlygate4sd3_1
Xhold245 _4704_/Q VGND VGND VPWR VPWR hold245/X sky130_fd_sc_hd__dlygate4sd3_1
Xhold256 _4510_/Q VGND VGND VPWR VPWR hold256/X sky130_fd_sc_hd__dlygate4sd3_1
X_3407_ _3407_/A _3407_/B VGND VGND VPWR VPWR _3407_/Y sky130_fd_sc_hd__nand2_1
X_4387_ _4538_/CLK _4387_/D fanout167/X VGND VGND VPWR VPWR hold22/A sky130_fd_sc_hd__dfrtp_1
Xhold289 _4509_/Q VGND VGND VPWR VPWR hold289/X sky130_fd_sc_hd__dlygate4sd3_1
X_3338_ _3554_/B2 _3336_/X _3337_/Y _3470_/B2 _4525_/Q VGND VGND VPWR VPWR _4525_/D
+ sky130_fd_sc_hd__a32o_1
XFILLER_105_57 VPWR VGND VPWR VGND sky130_ef_sc_hd__decap_12
XFILLER_100_533 VPWR VGND VPWR VGND sky130_ef_sc_hd__decap_12
XFILLER_85_244 VGND VGND VPWR VPWR sky130_fd_sc_hd__fill_1
XFILLER_85_222 VGND VGND VPWR VPWR sky130_fd_sc_hd__fill_2
XFILLER_58_447 VGND VGND VPWR VPWR sky130_fd_sc_hd__fill_1
XTAP_TAPCELL_ROW_69_987 VGND VPWR sky130_fd_sc_hd__tapvpwrvgnd_1
XFILLER_65_39 VPWR VGND VPWR VGND sky130_ef_sc_hd__decap_12
X_3269_ _2228_/Y _2226_/Y _2229_/Y _2227_/Y _3569_/S0 _3283_/S VGND VGND VPWR VPWR
+ _3270_/B sky130_fd_sc_hd__mux4_2
XFILLER_58_469 VGND VGND VPWR VPWR sky130_fd_sc_hd__decap_6
XFILLER_85_288 VPWR VGND VPWR VGND sky130_ef_sc_hd__decap_12
XFILLER_26_355 VGND VGND VPWR VPWR sky130_fd_sc_hd__fill_2
XFILLER_81_461 VPWR VGND VPWR VGND sky130_ef_sc_hd__decap_12
XFILLER_81_27 VPWR VGND VPWR VGND sky130_ef_sc_hd__decap_12
XPHY_EDGE_ROW_71_Right_71 VGND VGND VPWR VPWR sky130_fd_sc_hd__decap_3
XTAP_TAPCELL_ROW_24_501 VGND VPWR sky130_fd_sc_hd__tapvpwrvgnd_1
XTAP_TAPCELL_ROW_101_1345 VGND VPWR sky130_fd_sc_hd__tapvpwrvgnd_1
XFILLER_14_65 VPWR VGND VPWR VGND sky130_ef_sc_hd__decap_12
XFILLER_22_583 VGND VGND VPWR VPWR sky130_fd_sc_hd__decap_4
XFILLER_5_215 VGND VGND VPWR VPWR sky130_fd_sc_hd__decap_8
XPHY_EDGE_ROW_80_Right_80 VGND VGND VPWR VPWR sky130_fd_sc_hd__decap_3
XFILLER_5_248 VPWR VGND VPWR VGND sky130_ef_sc_hd__decap_12
XFILLER_30_53 VPWR VGND VPWR VGND sky130_ef_sc_hd__decap_12
XFILLER_107_165 VGND VGND VPWR VPWR sky130_fd_sc_hd__decap_3
XFILLER_89_561 VPWR VGND VPWR VGND sky130_ef_sc_hd__decap_12
XFILLER_39_51 VGND VGND VPWR VPWR sky130_fd_sc_hd__decap_4
XFILLER_103_393 VPWR VGND VPWR VGND sky130_ef_sc_hd__decap_12
XFILLER_76_233 VGND VGND VPWR VPWR sky130_fd_sc_hd__fill_1
XTAP_TAPCELL_ROW_4_281 VGND VPWR sky130_fd_sc_hd__tapvpwrvgnd_1
XFILLER_91_258 VGND VGND VPWR VPWR sky130_fd_sc_hd__decap_8
XFILLER_29_182 VGND VGND VPWR VPWR sky130_fd_sc_hd__decap_8
XFILLER_60_601 VPWR VGND VPWR VGND sky130_ef_sc_hd__decap_12
XFILLER_32_303 VGND VGND VPWR VPWR sky130_fd_sc_hd__decap_4
X_2640_ _2640_/A _2640_/B VGND VGND VPWR VPWR _2642_/B sky130_fd_sc_hd__xnor2_1
XTAP_TAPCELL_ROW_30_559 VGND VPWR sky130_fd_sc_hd__tapvpwrvgnd_1
X_2571_ _3382_/A _4522_/Q VGND VGND VPWR VPWR _2584_/A sky130_fd_sc_hd__nand2_1
XTAP_TAPCELL_ROW_78_1093 VGND VPWR sky130_fd_sc_hd__tapvpwrvgnd_1
X_4310_ hold37/A hold55/A hold52/A _4402_/Q _4436_/Q _2427_/B VGND VGND VPWR VPWR
+ _4311_/B sky130_fd_sc_hd__mux4_1
X_4241_ _4246_/C VGND VGND VPWR VPWR _4241_/Y sky130_fd_sc_hd__inv_2
X_4172_ _4206_/A1 _4170_/Y _4171_/X _4206_/B1 hold274/X VGND VGND VPWR VPWR _4689_/D
+ sky130_fd_sc_hd__a32o_1
XFILLER_95_553 VGND VGND VPWR VPWR sky130_fd_sc_hd__decap_6
X_3123_ _3123_/A _3123_/B VGND VGND VPWR VPWR _3124_/B sky130_fd_sc_hd__xnor2_1
XFILLER_95_597 VPWR VGND VPWR VGND sky130_ef_sc_hd__decap_12
X_3054_ _3054_/A _3054_/B VGND VGND VPWR VPWR _3055_/B sky130_fd_sc_hd__nand2_2
XFILLER_82_269 VPWR VGND VPWR VGND sky130_ef_sc_hd__decap_12
XTAP_TAPCELL_ROW_66_957 VGND VPWR sky130_fd_sc_hd__tapvpwrvgnd_1
XTAP_TAPCELL_ROW_38_648 VGND VPWR sky130_fd_sc_hd__tapvpwrvgnd_1
X_3956_ _3974_/A _3956_/B _3956_/C VGND VGND VPWR VPWR _3956_/X sky130_fd_sc_hd__or3_1
X_2907_ _2865_/A _2863_/X _2892_/B _2906_/X VGND VGND VPWR VPWR _2908_/A sky130_fd_sc_hd__o31ai_1
X_3887_ hold28/A _3887_/B VGND VGND VPWR VPWR _3889_/C sky130_fd_sc_hd__xor2_1
X_2838_ _4749_/Q _2839_/B VGND VGND VPWR VPWR _2838_/Y sky130_fd_sc_hd__nor2_1
X_2769_ _4532_/Q _2770_/B VGND VGND VPWR VPWR _2771_/A sky130_fd_sc_hd__nand2_1
X_4508_ _4750_/CLK _4508_/D fanout131/X VGND VGND VPWR VPWR _4508_/Q sky130_fd_sc_hd__dfrtp_1
X_4439_ _4726_/CLK _4439_/D fanout153/X VGND VGND VPWR VPWR _4439_/Q sky130_fd_sc_hd__dfrtp_1
XFILLER_86_531 VGND VGND VPWR VPWR sky130_fd_sc_hd__fill_1
XFILLER_76_27 VGND VGND VPWR VPWR sky130_fd_sc_hd__fill_1
XFILLER_100_363 VGND VGND VPWR VPWR sky130_fd_sc_hd__fill_1
XFILLER_92_15 VPWR VGND VPWR VGND sky130_ef_sc_hd__decap_12
XFILLER_73_269 VGND VGND VPWR VPWR sky130_fd_sc_hd__decap_8
XTAP_TAPCELL_ROW_1_240 VGND VPWR sky130_fd_sc_hd__tapvpwrvgnd_1
XFILLER_26_141 VGND VGND VPWR VPWR sky130_fd_sc_hd__decap_8
XFILLER_42_601 VPWR VGND VPWR VGND sky130_ef_sc_hd__decap_12
XFILLER_54_450 VGND VGND VPWR VPWR sky130_fd_sc_hd__fill_2
XFILLER_14_347 VGND VGND VPWR VPWR sky130_fd_sc_hd__decap_3
XPHY_EDGE_ROW_1_Left_109 VGND VGND VPWR VPWR sky130_fd_sc_hd__decap_3
XFILLER_41_100 VGND VGND VPWR VPWR sky130_fd_sc_hd__fill_2
XFILLER_10_586 VGND VGND VPWR VPWR sky130_fd_sc_hd__fill_2
XFILLER_10_597 VPWR VGND VPWR VGND sky130_ef_sc_hd__decap_12
XFILLER_92_501 VPWR VGND VPWR VGND sky130_ef_sc_hd__decap_12
XFILLER_77_553 VGND VGND VPWR VPWR sky130_fd_sc_hd__decap_6
XFILLER_49_266 VGND VGND VPWR VPWR sky130_fd_sc_hd__decap_4
XFILLER_77_597 VPWR VGND VPWR VGND sky130_ef_sc_hd__decap_12
XFILLER_92_545 VPWR VGND VPWR VGND sky130_ef_sc_hd__decap_12
XFILLER_92_589 VPWR VGND VPWR VGND sky130_ef_sc_hd__decap_12
XTAP_TAPCELL_ROW_63_927 VGND VPWR sky130_fd_sc_hd__tapvpwrvgnd_1
XTAP_TAPCELL_ROW_35_618 VGND VPWR sky130_fd_sc_hd__tapvpwrvgnd_1
XFILLER_32_100 VGND VGND VPWR VPWR sky130_fd_sc_hd__fill_1
X_3810_ _4545_/Q _3810_/B VGND VGND VPWR VPWR _3838_/B sky130_fd_sc_hd__xor2_1
XFILLER_60_464 VPWR VGND VPWR VGND sky130_ef_sc_hd__decap_12
XFILLER_60_453 VGND VGND VPWR VPWR sky130_fd_sc_hd__decap_3
X_3741_ _3741_/A _3741_/B VGND VGND VPWR VPWR _3742_/B sky130_fd_sc_hd__nand2_1
XFILLER_13_391 VGND VGND VPWR VPWR sky130_fd_sc_hd__fill_1
XTAP_TAPCELL_ROW_15_397 VGND VPWR sky130_fd_sc_hd__tapvpwrvgnd_1
XFILLER_70_3 VPWR VGND VPWR VGND sky130_ef_sc_hd__decap_12
XFILLER_9_362 VPWR VGND VPWR VGND sky130_ef_sc_hd__decap_12
X_3672_ _3672_/A _3672_/B VGND VGND VPWR VPWR _3672_/X sky130_fd_sc_hd__and2_1
X_2623_ _2623_/A _2623_/B VGND VGND VPWR VPWR _3417_/A sky130_fd_sc_hd__xor2_4
XFILLER_99_111 VGND VGND VPWR VPWR sky130_fd_sc_hd__fill_1
X_2554_ _4479_/Q _2555_/B VGND VGND VPWR VPWR _2554_/Y sky130_fd_sc_hd__nand2_1
XFILLER_101_105 VGND VGND VPWR VPWR sky130_fd_sc_hd__decap_6
X_2485_ _4457_/Q _2485_/B VGND VGND VPWR VPWR _2485_/X sky130_fd_sc_hd__or2_1
XFILLER_68_531 VGND VGND VPWR VPWR sky130_fd_sc_hd__fill_1
X_4224_ _4225_/A _4225_/B VGND VGND VPWR VPWR _4224_/Y sky130_fd_sc_hd__nand2_1
XFILLER_101_149 VPWR VGND VPWR VGND sky130_ef_sc_hd__decap_12
X_4155_ _4155_/A1 _4026_/X _4095_/Y _4149_/Y hold65/X VGND VGND VPWR VPWR _4682_/D
+ sky130_fd_sc_hd__a32o_1
XFILLER_95_361 VPWR VGND VPWR VGND sky130_ef_sc_hd__decap_12
X_3106_ _3106_/A _3106_/B _3105_/B _3105_/C VGND VGND VPWR VPWR _3106_/X sky130_fd_sc_hd__or4bb_1
XFILLER_55_225 VGND VGND VPWR VPWR sky130_fd_sc_hd__decap_4
X_4086_ hold234/X _4728_/Q _4093_/S VGND VGND VPWR VPWR _4621_/D sky130_fd_sc_hd__mux2_1
XFILLER_55_236 VPWR VGND VPWR VGND sky130_ef_sc_hd__decap_12
X_3037_ _4757_/Q _3038_/B VGND VGND VPWR VPWR _3037_/Y sky130_fd_sc_hd__nor2_1
XFILLER_24_634 VGND VGND VPWR VPWR sky130_fd_sc_hd__decap_3
XFILLER_51_420 VPWR VGND VPWR VGND sky130_ef_sc_hd__decap_12
XFILLER_62_29 VPWR VGND VPWR VGND sky130_ef_sc_hd__decap_12
XFILLER_23_166 VGND VGND VPWR VPWR sky130_fd_sc_hd__fill_2
XFILLER_23_177 VGND VGND VPWR VPWR sky130_fd_sc_hd__decap_4
XFILLER_23_188 VPWR VGND VPWR VGND sky130_ef_sc_hd__decap_12
X_3939_ _4650_/Q _4586_/Q hold65/A hold41/A _3983_/S0 _3983_/S1 VGND VGND VPWR VPWR
+ _3941_/B sky130_fd_sc_hd__mux4_1
XFILLER_11_55 VGND VGND VPWR VPWR sky130_fd_sc_hd__fill_1
XFILLER_3_505 VGND VGND VPWR VPWR sky130_fd_sc_hd__decap_6
XFILLER_87_15 VPWR VGND VPWR VGND sky130_ef_sc_hd__decap_12
XFILLER_93_309 VGND VGND VPWR VPWR sky130_fd_sc_hd__decap_8
XFILLER_59_553 VGND VGND VPWR VPWR sky130_fd_sc_hd__decap_6
XFILLER_74_501 VPWR VGND VPWR VGND sky130_ef_sc_hd__decap_12
XFILLER_59_597 VPWR VGND VPWR VGND sky130_ef_sc_hd__decap_12
XFILLER_74_545 VPWR VGND VPWR VGND sky130_ef_sc_hd__decap_12
XFILLER_74_589 VPWR VGND VPWR VGND sky130_ef_sc_hd__decap_12
XFILLER_36_41 VPWR VGND VPWR VGND sky130_ef_sc_hd__decap_12
XFILLER_15_634 VGND VGND VPWR VPWR sky130_fd_sc_hd__decap_3
XFILLER_36_85 VGND VGND VPWR VPWR sky130_fd_sc_hd__decap_4
XFILLER_54_280 VPWR VGND VPWR VGND sky130_ef_sc_hd__decap_12
XFILLER_14_166 VGND VGND VPWR VPWR sky130_fd_sc_hd__decap_4
XTAP_TAPCELL_ROW_12_367 VGND VPWR sky130_fd_sc_hd__tapvpwrvgnd_1
XTAP_TAPCELL_ROW_40_676 VGND VPWR sky130_fd_sc_hd__tapvpwrvgnd_1
XTAP_TAPCELL_ROW_75_1052 VGND VPWR sky130_fd_sc_hd__tapvpwrvgnd_1
XFILLER_97_615 VGND VGND VPWR VPWR sky130_fd_sc_hd__fill_1
XFILLER_2_571 VPWR VGND VPWR VGND sky130_ef_sc_hd__decap_12
X_2270_ _2206_/Y _4466_/Q _4240_/A _4465_/Q VGND VGND VPWR VPWR _2270_/X sky130_fd_sc_hd__o22a_1
XFILLER_37_225 VGND VGND VPWR VPWR sky130_fd_sc_hd__fill_1
XTAP_TAPCELL_ROW_48_765 VGND VPWR sky130_fd_sc_hd__tapvpwrvgnd_1
XTAP_TAPCELL_ROW_86_1181 VGND VPWR sky130_fd_sc_hd__tapvpwrvgnd_1
X_3724_ _3756_/B _3724_/B VGND VGND VPWR VPWR _3727_/A sky130_fd_sc_hd__or2_1
X_3655_ hold94/A _4574_/Q _4670_/Q _4606_/Q _3915_/S0 _3915_/S1 VGND VGND VPWR VPWR
+ _3657_/B sky130_fd_sc_hd__mux4_1
X_2606_ hold300/X _4331_/A2 _3396_/A _4331_/B2 VGND VGND VPWR VPWR _4492_/D sky130_fd_sc_hd__a22o_1
X_3586_ _4535_/Q _3551_/B _3584_/X VGND VGND VPWR VPWR _3586_/Y sky130_fd_sc_hd__o21ai_1
X_2537_ _4474_/Q _4473_/Q VGND VGND VPWR VPWR _2537_/X sky130_fd_sc_hd__or2_1
X_2468_ _2468_/A VGND VGND VPWR VPWR _2471_/B sky130_fd_sc_hd__inv_2
XFILLER_102_469 VGND VGND VPWR VPWR sky130_fd_sc_hd__decap_6
XFILLER_87_169 VGND VGND VPWR VPWR sky130_fd_sc_hd__decap_6
X_4207_ _4700_/Q _4208_/B VGND VGND VPWR VPWR _4207_/X sky130_fd_sc_hd__or2_1
X_2399_ hold49/X _2408_/A2 _2408_/B1 _4500_/Q VGND VGND VPWR VPWR hold50/A sky130_fd_sc_hd__a22o_1
XFILLER_83_320 VGND VGND VPWR VPWR sky130_fd_sc_hd__decap_3
XFILLER_28_236 VPWR VGND VPWR VGND sky130_ef_sc_hd__decap_12
X_4138_ hold179/X _4138_/A1 _4139_/S VGND VGND VPWR VPWR _4667_/D sky130_fd_sc_hd__mux2_1
XFILLER_56_545 VPWR VGND VPWR VGND sky130_ef_sc_hd__decap_12
X_4069_ _4132_/A1 hold153/X _4076_/S VGND VGND VPWR VPWR _4605_/D sky130_fd_sc_hd__mux2_1
XFILLER_56_589 VPWR VGND VPWR VGND sky130_ef_sc_hd__decap_12
XFILLER_73_39 VPWR VGND VPWR VGND sky130_ef_sc_hd__decap_12
XFILLER_71_559 VGND VGND VPWR VPWR sky130_fd_sc_hd__fill_1
XFILLER_11_169 VGND VGND VPWR VPWR sky130_fd_sc_hd__fill_1
XFILLER_22_65 VPWR VGND VPWR VGND sky130_ef_sc_hd__decap_12
XFILLER_79_615 VGND VGND VPWR VPWR sky130_fd_sc_hd__fill_1
XFILLER_0_3 VGND VGND VPWR VPWR sky130_fd_sc_hd__decap_6
XFILLER_66_309 VPWR VGND VPWR VGND sky130_ef_sc_hd__decap_12
XFILLER_59_383 VGND VGND VPWR VPWR sky130_fd_sc_hd__fill_1
Xfanout160 fanout163/X VGND VGND VPWR VPWR fanout160/X sky130_fd_sc_hd__clkbuf_4
Xfanout171 fanout172/X VGND VGND VPWR VPWR fanout171/X sky130_fd_sc_hd__buf_2
XFILLER_47_51 VGND VGND VPWR VPWR sky130_fd_sc_hd__decap_4
XFILLER_47_545 VGND VGND VPWR VPWR sky130_fd_sc_hd__decap_3
XFILLER_15_420 VGND VGND VPWR VPWR sky130_fd_sc_hd__decap_4
XTAP_TAPCELL_ROW_17_415 VGND VPWR sky130_fd_sc_hd__tapvpwrvgnd_1
XTAP_TAPCELL_ROW_45_724 VGND VPWR sky130_fd_sc_hd__tapvpwrvgnd_1
XFILLER_70_581 VGND VGND VPWR VPWR sky130_fd_sc_hd__decap_6
XFILLER_42_261 VPWR VGND VPWR VGND sky130_ef_sc_hd__decap_12
XFILLER_30_489 VGND VGND VPWR VPWR sky130_fd_sc_hd__decap_8
X_3440_ _3440_/A _3440_/B VGND VGND VPWR VPWR _3441_/B sky130_fd_sc_hd__and2_1
X_3371_ _4626_/Q _4562_/Q _4658_/Q _4594_/Q _3569_/S0 _3283_/S VGND VGND VPWR VPWR
+ _3373_/B sky130_fd_sc_hd__mux4_2
XFILLER_33_3 VPWR VGND VPWR VGND sky130_ef_sc_hd__decap_12
X_2322_ _2356_/A _4770_/Q _2324_/B _2534_/A2 VGND VGND VPWR VPWR _4770_/D sky130_fd_sc_hd__a31o_1
XFILLER_85_629 VGND VGND VPWR VPWR sky130_fd_sc_hd__decap_8
X_2253_ _2431_/A _4770_/Q VGND VGND VPWR VPWR _2256_/B sky130_fd_sc_hd__nor2_1
X_2184_ _4443_/Q VGND VGND VPWR VPWR _2438_/A sky130_fd_sc_hd__inv_2
XFILLER_80_301 VGND VGND VPWR VPWR sky130_fd_sc_hd__decap_6
XFILLER_38_589 VGND VGND VPWR VPWR sky130_fd_sc_hd__decap_3
XFILLER_65_397 VGND VGND VPWR VPWR sky130_fd_sc_hd__fill_1
XFILLER_25_239 VGND VGND VPWR VPWR sky130_fd_sc_hd__decap_3
XFILLER_80_389 VPWR VGND VPWR VGND sky130_ef_sc_hd__decap_12
XFILLER_21_412 VGND VGND VPWR VPWR sky130_fd_sc_hd__fill_2
XFILLER_40_209 VGND VGND VPWR VPWR sky130_fd_sc_hd__decap_8
X_4756_ _4756_/CLK _4756_/D fanout137/X VGND VGND VPWR VPWR _4756_/Q sky130_fd_sc_hd__dfrtp_1
XFILLER_107_517 VPWR VGND VPWR VGND sky130_ef_sc_hd__decap_12
X_3707_ _3707_/A _3730_/A VGND VGND VPWR VPWR _3720_/C sky130_fd_sc_hd__nand2_1
X_4687_ _4727_/CLK _4687_/D fanout156/X VGND VGND VPWR VPWR _4687_/Q sky130_fd_sc_hd__dfrtp_1
X_3638_ _3638_/A _3638_/B _3638_/C VGND VGND VPWR VPWR _3640_/A sky130_fd_sc_hd__or3_1
X_3569_ hold67/A hold77/A _4667_/Q _4603_/Q _3569_/S0 _3519_/S VGND VGND VPWR VPWR
+ _3572_/B sky130_fd_sc_hd__mux4_2
XFILLER_102_233 VPWR VGND VPWR VGND sky130_ef_sc_hd__decap_12
XFILLER_88_445 VPWR VGND VPWR VGND sky130_ef_sc_hd__decap_12
XFILLER_0_349 VPWR VGND VPWR VGND sky130_ef_sc_hd__decap_12
XFILLER_102_277 VPWR VGND VPWR VGND sky130_ef_sc_hd__decap_12
XFILLER_88_489 VPWR VGND VPWR VGND sky130_ef_sc_hd__decap_12
XFILLER_48_309 VGND VGND VPWR VPWR sky130_fd_sc_hd__fill_2
XFILLER_84_27 VGND VGND VPWR VPWR sky130_fd_sc_hd__fill_1
XFILLER_68_191 VGND VGND VPWR VPWR sky130_fd_sc_hd__decap_4
XFILLER_44_504 VGND VGND VPWR VPWR sky130_fd_sc_hd__fill_1
XTAP_TAPCELL_ROW_104_1376 VGND VPWR sky130_fd_sc_hd__tapvpwrvgnd_1
XTAP_TAPCELL_ROW_22_473 VGND VPWR sky130_fd_sc_hd__tapvpwrvgnd_1
XTAP_TAPCELL_ROW_50_782 VGND VPWR sky130_fd_sc_hd__tapvpwrvgnd_1
XFILLER_98_209 VPWR VGND VPWR VGND sky130_ef_sc_hd__decap_12
XFILLER_79_412 VGND VGND VPWR VPWR sky130_fd_sc_hd__fill_1
XTAP_TAPCELL_ROW_72_1022 VGND VPWR sky130_fd_sc_hd__tapvpwrvgnd_1
XFILLER_67_629 VGND VGND VPWR VPWR sky130_fd_sc_hd__decap_8
XFILLER_58_83 VGND VGND VPWR VPWR sky130_fd_sc_hd__fill_1
Xhold5 hold5/A VGND VGND VPWR VPWR hold5/X sky130_fd_sc_hd__dlygate4sd3_1
XFILLER_58_94 VGND VGND VPWR VPWR sky130_fd_sc_hd__decap_4
XFILLER_35_526 VGND VGND VPWR VPWR sky130_fd_sc_hd__fill_1
XTAP_TAPCELL_ROW_58_871 VGND VPWR sky130_fd_sc_hd__tapvpwrvgnd_1
XFILLER_35_559 VGND VGND VPWR VPWR sky130_fd_sc_hd__fill_1
XTAP_TAPCELL_ROW_83_1140 VGND VPWR sky130_fd_sc_hd__tapvpwrvgnd_1
XFILLER_62_389 VPWR VGND VPWR VGND sky130_ef_sc_hd__decap_12
XFILLER_15_250 VPWR VGND VPWR VGND sky130_ef_sc_hd__decap_12
X_2940_ _2963_/A _2911_/B _2905_/A VGND VGND VPWR VPWR _2941_/B sky130_fd_sc_hd__o21a_1
X_2871_ _2871_/A _2871_/B VGND VGND VPWR VPWR _2871_/X sky130_fd_sc_hd__or2_1
X_4610_ _4676_/CLK _4610_/D fanout134/X VGND VGND VPWR VPWR _4610_/Q sky130_fd_sc_hd__dfrtp_1
XFILLER_30_253 VGND VGND VPWR VPWR sky130_fd_sc_hd__decap_3
X_4541_ _4542_/CLK _4541_/D fanout168/X VGND VGND VPWR VPWR _4541_/Q sky130_fd_sc_hd__dfrtp_4
X_4472_ _4716_/CLK _4472_/D fanout162/X VGND VGND VPWR VPWR _4472_/Q sky130_fd_sc_hd__dfrtp_1
X_3423_ _3423_/A _3423_/B VGND VGND VPWR VPWR _3425_/B sky130_fd_sc_hd__xnor2_1
X_3354_ _3353_/A _3353_/B _3353_/C VGND VGND VPWR VPWR _3355_/B sky130_fd_sc_hd__a21oi_1
X_3285_ _3287_/A _3287_/B VGND VGND VPWR VPWR _3304_/A sky130_fd_sc_hd__nand2_1
X_2305_ _4700_/Q _4456_/Q VGND VGND VPWR VPWR _2312_/C sky130_fd_sc_hd__and2b_1
X_2236_ _4727_/Q _4718_/Q VGND VGND VPWR VPWR _2236_/Y sky130_fd_sc_hd__nand2b_1
XFILLER_72_109 VGND VGND VPWR VPWR sky130_fd_sc_hd__decap_6
XFILLER_65_183 VGND VGND VPWR VPWR sky130_fd_sc_hd__fill_1
XFILLER_53_334 VGND VGND VPWR VPWR sky130_fd_sc_hd__fill_2
XFILLER_41_529 VPWR VGND VPWR VGND sky130_ef_sc_hd__decap_12
XFILLER_53_389 VGND VGND VPWR VPWR sky130_fd_sc_hd__decap_3
XFILLER_80_197 VGND VGND VPWR VPWR sky130_fd_sc_hd__fill_1
XFILLER_70_29 VPWR VGND VPWR VGND sky130_ef_sc_hd__decap_12
X_4739_ _4739_/CLK _4739_/D fanout129/X VGND VGND VPWR VPWR _4739_/Q sky130_fd_sc_hd__dfrtp_1
XFILLER_79_27 VPWR VGND VPWR VGND sky130_ef_sc_hd__decap_12
XFILLER_103_553 VGND VGND VPWR VPWR sky130_fd_sc_hd__decap_6
XFILLER_88_220 VGND VGND VPWR VPWR sky130_fd_sc_hd__decap_3
XFILLER_0_113 VGND VGND VPWR VPWR sky130_fd_sc_hd__decap_8
XFILLER_49_607 VGND VGND VPWR VPWR sky130_fd_sc_hd__decap_8
XFILLER_95_15 VPWR VGND VPWR VGND sky130_ef_sc_hd__decap_12
XFILLER_88_275 VGND VGND VPWR VPWR sky130_fd_sc_hd__decap_8
XFILLER_49_629 VGND VGND VPWR VPWR sky130_fd_sc_hd__decap_8
XFILLER_103_597 VPWR VGND VPWR VGND sky130_ef_sc_hd__decap_12
XFILLER_48_139 VGND VGND VPWR VPWR sky130_fd_sc_hd__fill_1
XFILLER_28_53 VPWR VGND VPWR VGND sky130_ef_sc_hd__decap_12
XFILLER_91_429 VPWR VGND VPWR VGND sky130_ef_sc_hd__decap_12
XFILLER_29_397 VPWR VGND VPWR VGND sky130_ef_sc_hd__decap_12
XFILLER_56_150 VGND VGND VPWR VPWR sky130_fd_sc_hd__fill_1
XTAP_TAPCELL_ROW_27_532 VGND VPWR sky130_fd_sc_hd__tapvpwrvgnd_1
XTAP_TAPCELL_ROW_55_841 VGND VPWR sky130_fd_sc_hd__tapvpwrvgnd_1
XFILLER_56_194 VGND VGND VPWR VPWR sky130_fd_sc_hd__fill_2
XFILLER_44_41 VPWR VGND VPWR VGND sky130_ef_sc_hd__decap_12
XFILLER_12_220 VGND VGND VPWR VPWR sky130_fd_sc_hd__fill_1
XFILLER_44_85 VGND VGND VPWR VPWR sky130_fd_sc_hd__decap_6
XFILLER_12_253 VPWR VGND VPWR VGND sky130_ef_sc_hd__decap_12
XFILLER_99_529 VPWR VGND VPWR VGND sky130_ef_sc_hd__decap_12
XFILLER_5_57 VPWR VGND VPWR VGND sky130_ef_sc_hd__decap_12
XFILLER_4_463 VPWR VGND VPWR VGND sky130_ef_sc_hd__decap_12
XFILLER_79_297 VGND VGND VPWR VPWR sky130_fd_sc_hd__fill_1
X_3070_ _3022_/A _3022_/B _3049_/A _3069_/X VGND VGND VPWR VPWR _3071_/B sky130_fd_sc_hd__a31o_1
XFILLER_82_407 VGND VGND VPWR VPWR sky130_fd_sc_hd__fill_1
XFILLER_94_289 VPWR VGND VPWR VGND sky130_ef_sc_hd__decap_12
XFILLER_35_323 VGND VGND VPWR VPWR sky130_fd_sc_hd__fill_1
X_3972_ _3973_/B _4552_/Q VGND VGND VPWR VPWR _3972_/Y sky130_fd_sc_hd__nand2b_1
XFILLER_62_197 VPWR VGND VPWR VGND sky130_ef_sc_hd__decap_12
X_2923_ _2922_/B _2922_/C _2922_/A VGND VGND VPWR VPWR _2924_/B sky130_fd_sc_hd__o21ai_1
XTAP_TAPCELL_ROW_61_899 VGND VPWR sky130_fd_sc_hd__tapvpwrvgnd_1
XFILLER_31_573 VGND VGND VPWR VPWR sky130_fd_sc_hd__fill_1
X_2854_ _2855_/A _2855_/B VGND VGND VPWR VPWR _2854_/Y sky130_fd_sc_hd__nand2_1
X_2785_ hold251/X _4339_/A2 _3556_/A _4339_/B2 VGND VGND VPWR VPWR _4500_/D sky130_fd_sc_hd__a22o_1
X_4524_ _4734_/CLK _4524_/D fanout146/X VGND VGND VPWR VPWR _4524_/Q sky130_fd_sc_hd__dfrtp_4
Xhold202 _4492_/Q VGND VGND VPWR VPWR hold202/X sky130_fd_sc_hd__dlygate4sd3_1
Xhold235 _4435_/Q VGND VGND VPWR VPWR hold235/X sky130_fd_sc_hd__dlygate4sd3_1
Xhold224 _4356_/Q VGND VGND VPWR VPWR hold224/X sky130_fd_sc_hd__dlygate4sd3_1
Xhold213 _4479_/Q VGND VGND VPWR VPWR hold213/X sky130_fd_sc_hd__dlygate4sd3_1
XTAP_TAPCELL_ROW_92_1239 VGND VPWR sky130_fd_sc_hd__tapvpwrvgnd_1
Xhold257 _4442_/Q VGND VGND VPWR VPWR hold257/X sky130_fd_sc_hd__dlygate4sd3_1
Xhold268 _4695_/Q VGND VGND VPWR VPWR hold268/X sky130_fd_sc_hd__dlygate4sd3_1
Xhold246 _4554_/Q VGND VGND VPWR VPWR _3995_/A sky130_fd_sc_hd__dlygate4sd3_1
X_4455_ _4699_/CLK _4455_/D fanout158/X VGND VGND VPWR VPWR _4455_/Q sky130_fd_sc_hd__dfrtp_1
X_3406_ _3407_/A _3407_/B VGND VGND VPWR VPWR _3406_/X sky130_fd_sc_hd__or2_1
Xhold279 _4768_/Q VGND VGND VPWR VPWR hold279/X sky130_fd_sc_hd__dlygate4sd3_1
X_4386_ _4538_/CLK _4386_/D fanout167/X VGND VGND VPWR VPWR hold55/A sky130_fd_sc_hd__dfrtp_1
XFILLER_100_501 VPWR VGND VPWR VGND sky130_ef_sc_hd__decap_12
X_3337_ _3337_/A _3337_/B VGND VGND VPWR VPWR _3337_/Y sky130_fd_sc_hd__nand2_1
XFILLER_100_545 VPWR VGND VPWR VGND sky130_ef_sc_hd__decap_12
XFILLER_105_69 VPWR VGND VPWR VGND sky130_ef_sc_hd__decap_12
XTAP_TAPCELL_ROW_69_988 VGND VPWR sky130_fd_sc_hd__tapvpwrvgnd_1
X_3268_ _4747_/Q _3543_/D VGND VGND VPWR VPWR _3268_/Y sky130_fd_sc_hd__xnor2_1
XFILLER_58_459 VGND VGND VPWR VPWR sky130_fd_sc_hd__fill_2
XFILLER_100_589 VPWR VGND VPWR VGND sky130_ef_sc_hd__decap_12
X_3199_ _3836_/A _4550_/Q VGND VGND VPWR VPWR _3201_/A sky130_fd_sc_hd__and2_1
XFILLER_73_429 VPWR VGND VPWR VGND sky130_ef_sc_hd__decap_12
X_2219_ _4741_/Q VGND VGND VPWR VPWR _3369_/A sky130_fd_sc_hd__inv_2
XFILLER_38_150 VGND VGND VPWR VPWR sky130_fd_sc_hd__fill_2
XFILLER_26_334 VGND VGND VPWR VPWR sky130_fd_sc_hd__fill_1
XFILLER_81_473 VPWR VGND VPWR VGND sky130_ef_sc_hd__decap_12
XTAP_TAPCELL_ROW_52_800 VGND VPWR sky130_fd_sc_hd__tapvpwrvgnd_1
XFILLER_81_39 VPWR VGND VPWR VGND sky130_ef_sc_hd__decap_12
XTAP_TAPCELL_ROW_101_1346 VGND VPWR sky130_fd_sc_hd__tapvpwrvgnd_1
XFILLER_14_77 VGND VGND VPWR VPWR sky130_fd_sc_hd__decap_6
XFILLER_30_65 VPWR VGND VPWR VGND sky130_ef_sc_hd__decap_12
XFILLER_100_3 VPWR VGND VPWR VGND sky130_ef_sc_hd__decap_12
XFILLER_103_361 VPWR VGND VPWR VGND sky130_ef_sc_hd__decap_12
XFILLER_89_573 VPWR VGND VPWR VGND sky130_ef_sc_hd__decap_12
XFILLER_76_245 VGND VGND VPWR VPWR sky130_fd_sc_hd__fill_2
XFILLER_64_407 VGND VGND VPWR VPWR sky130_fd_sc_hd__fill_1
XTAP_TAPCELL_ROW_4_271 VGND VPWR sky130_fd_sc_hd__tapvpwrvgnd_1
XFILLER_57_470 VPWR VGND VPWR VGND sky130_ef_sc_hd__decap_12
XFILLER_55_51 VGND VGND VPWR VPWR sky130_fd_sc_hd__decap_4
XFILLER_72_462 VPWR VGND VPWR VGND sky130_ef_sc_hd__decap_12
XFILLER_60_613 VPWR VGND VPWR VGND sky130_ef_sc_hd__decap_12
XTAP_TAPCELL_ROW_80_1110 VGND VPWR sky130_fd_sc_hd__tapvpwrvgnd_1
XFILLER_32_315 VGND VGND VPWR VPWR sky130_fd_sc_hd__fill_1
X_2570_ _2581_/A _2570_/B VGND VGND VPWR VPWR _2574_/A sky130_fd_sc_hd__and2_1
XTAP_TAPCELL_ROW_78_1094 VGND VPWR sky130_fd_sc_hd__tapvpwrvgnd_1
XFILLER_99_337 VPWR VGND VPWR VGND sky130_ef_sc_hd__decap_12
X_4240_ _4240_/A _4240_/B VGND VGND VPWR VPWR _4246_/C sky130_fd_sc_hd__nor2_1
X_4171_ _4688_/Q _4169_/C _4689_/Q VGND VGND VPWR VPWR _4171_/X sky130_fd_sc_hd__a21o_1
X_3122_ _3122_/A _3122_/B VGND VGND VPWR VPWR _3123_/B sky130_fd_sc_hd__nor2_1
XFILLER_67_223 VGND VGND VPWR VPWR sky130_fd_sc_hd__fill_1
XFILLER_67_212 VGND VGND VPWR VPWR sky130_fd_sc_hd__decap_3
X_3053_ _4511_/Q _3053_/B VGND VGND VPWR VPWR _3104_/B sky130_fd_sc_hd__xnor2_4
XTAP_TAPCELL_ROW_66_958 VGND VPWR sky130_fd_sc_hd__tapvpwrvgnd_1
XFILLER_63_440 VGND VGND VPWR VPWR sky130_fd_sc_hd__fill_1
XTAP_TAPCELL_ROW_38_649 VGND VPWR sky130_fd_sc_hd__tapvpwrvgnd_1
XFILLER_90_292 VGND VGND VPWR VPWR sky130_fd_sc_hd__decap_8
XFILLER_23_337 VGND VGND VPWR VPWR sky130_fd_sc_hd__decap_4
XFILLER_50_112 VGND VGND VPWR VPWR sky130_fd_sc_hd__decap_8
X_3955_ _3974_/A _3956_/B _3956_/C VGND VGND VPWR VPWR _3955_/Y sky130_fd_sc_hd__o21ai_1
X_2906_ _2862_/A _2884_/Y _2886_/B VGND VGND VPWR VPWR _2906_/X sky130_fd_sc_hd__o21a_1
X_3886_ hold28/A _3887_/B VGND VGND VPWR VPWR _3886_/Y sky130_fd_sc_hd__nand2_1
X_2837_ hold78/A _4602_/Q hold73/A _4666_/Q _2746_/S _2837_/S1 VGND VGND VPWR VPWR
+ _2839_/B sky130_fd_sc_hd__mux4_1
X_2768_ _4528_/Q _4537_/Q VGND VGND VPWR VPWR _2770_/B sky130_fd_sc_hd__xor2_1
XFILLER_105_615 VGND VGND VPWR VPWR sky130_fd_sc_hd__fill_1
X_2699_ _2698_/B _2698_/C _4529_/Q VGND VGND VPWR VPWR _2700_/B sky130_fd_sc_hd__a21o_1
X_4507_ _4539_/CLK _4507_/D fanout143/X VGND VGND VPWR VPWR _4507_/Q sky130_fd_sc_hd__dfrtp_1
X_4438_ _4481_/CLK _4438_/D fanout153/X VGND VGND VPWR VPWR _4438_/Q sky130_fd_sc_hd__dfrtp_1
X_4369_ _4726_/CLK _4369_/D fanout160/X VGND VGND VPWR VPWR hold1/A sky130_fd_sc_hd__dfrtp_1
XFILLER_86_587 VGND VGND VPWR VPWR sky130_fd_sc_hd__fill_1
XFILLER_92_27 VGND VGND VPWR VPWR sky130_fd_sc_hd__fill_1
XTAP_TAPCELL_ROW_1_241 VGND VPWR sky130_fd_sc_hd__tapvpwrvgnd_1
XFILLER_39_492 VPWR VGND VPWR VGND sky130_ef_sc_hd__decap_12
XFILLER_42_613 VGND VGND VPWR VPWR sky130_fd_sc_hd__fill_1
XFILLER_41_167 VGND VGND VPWR VPWR sky130_fd_sc_hd__fill_1
XFILLER_41_189 VGND VGND VPWR VPWR sky130_fd_sc_hd__fill_1
XFILLER_10_521 VGND VGND VPWR VPWR sky130_fd_sc_hd__fill_1
XTAP_TAPCELL_ROW_9_330 VGND VPWR sky130_fd_sc_hd__tapvpwrvgnd_1
XFILLER_96_307 VGND VGND VPWR VPWR sky130_fd_sc_hd__fill_1
XFILLER_49_212 VPWR VGND VPWR VGND sky130_ef_sc_hd__decap_12
XFILLER_1_296 VGND VGND VPWR VPWR sky130_fd_sc_hd__fill_1
XFILLER_92_513 VPWR VGND VPWR VGND sky130_ef_sc_hd__decap_12
XFILLER_37_418 VGND VGND VPWR VPWR sky130_fd_sc_hd__fill_2
XFILLER_92_557 VPWR VGND VPWR VGND sky130_ef_sc_hd__decap_12
XFILLER_66_83 VGND VGND VPWR VPWR sky130_fd_sc_hd__fill_1
XTAP_TAPCELL_ROW_63_928 VGND VPWR sky130_fd_sc_hd__tapvpwrvgnd_1
XTAP_TAPCELL_ROW_35_619 VGND VPWR sky130_fd_sc_hd__tapvpwrvgnd_1
XFILLER_60_421 VGND VGND VPWR VPWR sky130_fd_sc_hd__fill_1
XFILLER_17_197 VPWR VGND VPWR VGND sky130_ef_sc_hd__decap_12
X_3740_ _3740_/A _3740_/B _3740_/C VGND VGND VPWR VPWR _3741_/B sky130_fd_sc_hd__nand3_1
XFILLER_20_307 VGND VGND VPWR VPWR sky130_fd_sc_hd__fill_1
XTAP_TAPCELL_ROW_15_398 VGND VPWR sky130_fd_sc_hd__tapvpwrvgnd_1
X_3671_ _3720_/A _3720_/B VGND VGND VPWR VPWR _3674_/A sky130_fd_sc_hd__xnor2_1
XFILLER_63_3 VPWR VGND VPWR VGND sky130_ef_sc_hd__decap_12
X_2622_ _2605_/A _2605_/B _2602_/X VGND VGND VPWR VPWR _2623_/B sky130_fd_sc_hd__a21o_1
X_2553_ _2432_/A _2551_/Y _2552_/X _3813_/A2 hold91/X VGND VGND VPWR VPWR _4478_/D
+ sky130_fd_sc_hd__a32o_1
XFILLER_99_167 VGND VGND VPWR VPWR sky130_fd_sc_hd__fill_1
X_2484_ _4457_/Q _2485_/B VGND VGND VPWR VPWR _2488_/B sky130_fd_sc_hd__nand2_1
X_4223_ _4238_/A1 _4221_/X _4225_/B _4238_/B1 hold245/X VGND VGND VPWR VPWR _4704_/D
+ sky130_fd_sc_hd__a32o_1
X_4154_ _4155_/A1 _4024_/X _4140_/D _4149_/Y hold118/X VGND VGND VPWR VPWR _4681_/D
+ sky130_fd_sc_hd__a32o_1
XFILLER_95_373 VPWR VGND VPWR VGND sky130_ef_sc_hd__decap_12
XFILLER_68_587 VGND VGND VPWR VPWR sky130_fd_sc_hd__fill_1
X_3105_ _3105_/A _3105_/B _3105_/C VGND VGND VPWR VPWR _3105_/Y sky130_fd_sc_hd__nand3_1
X_4085_ _4095_/A _4085_/B VGND VGND VPWR VPWR _4093_/S sky130_fd_sc_hd__nor2_4
XFILLER_55_204 VGND VGND VPWR VPWR sky130_fd_sc_hd__fill_1
X_3036_ _4578_/Q _4610_/Q _4642_/Q _4674_/Q _4324_/S _3174_/S1 VGND VGND VPWR VPWR
+ _3038_/B sky130_fd_sc_hd__mux4_1
XFILLER_55_248 VGND VGND VPWR VPWR sky130_fd_sc_hd__decap_8
XFILLER_102_15 VPWR VGND VPWR VGND sky130_ef_sc_hd__decap_12
XFILLER_63_281 VPWR VGND VPWR VGND sky130_ef_sc_hd__decap_12
XFILLER_51_432 VGND VGND VPWR VPWR sky130_fd_sc_hd__decap_8
X_3938_ _4765_/Q _3938_/B VGND VGND VPWR VPWR _3941_/A sky130_fd_sc_hd__xnor2_1
X_3869_ _3869_/A _3869_/B VGND VGND VPWR VPWR _3869_/Y sky130_fd_sc_hd__xnor2_1
XFILLER_87_27 VPWR VGND VPWR VGND sky130_ef_sc_hd__decap_12
XTAP_TAPCELL_ROW_6_300 VGND VPWR sky130_fd_sc_hd__tapvpwrvgnd_1
XFILLER_74_513 VPWR VGND VPWR VGND sky130_ef_sc_hd__decap_12
XFILLER_19_418 VGND VGND VPWR VPWR sky130_fd_sc_hd__fill_1
XFILLER_74_557 VPWR VGND VPWR VGND sky130_ef_sc_hd__decap_12
XFILLER_15_602 VPWR VGND VPWR VGND sky130_ef_sc_hd__decap_12
XFILLER_36_53 VPWR VGND VPWR VGND sky130_ef_sc_hd__decap_12
XFILLER_54_292 VGND VGND VPWR VPWR sky130_fd_sc_hd__decap_4
XFILLER_14_156 VGND VGND VPWR VPWR sky130_fd_sc_hd__fill_1
XFILLER_52_41 VPWR VGND VPWR VGND sky130_ef_sc_hd__decap_12
XTAP_TAPCELL_ROW_12_368 VGND VPWR sky130_fd_sc_hd__tapvpwrvgnd_1
XFILLER_10_362 VGND VGND VPWR VPWR sky130_fd_sc_hd__fill_2
XTAP_TAPCELL_ROW_40_677 VGND VPWR sky130_fd_sc_hd__tapvpwrvgnd_1
XFILLER_10_373 VGND VGND VPWR VPWR sky130_fd_sc_hd__decap_3
XFILLER_6_322 VGND VGND VPWR VPWR sky130_fd_sc_hd__decap_4
XTAP_TAPCELL_ROW_75_1053 VGND VPWR sky130_fd_sc_hd__tapvpwrvgnd_1
XFILLER_2_583 VGND VGND VPWR VPWR sky130_fd_sc_hd__decap_4
XFILLER_92_321 VGND VGND VPWR VPWR sky130_fd_sc_hd__fill_1
XTAP_TAPCELL_ROW_48_755 VGND VPWR sky130_fd_sc_hd__tapvpwrvgnd_1
XFILLER_93_81 VPWR VGND VPWR VGND sky130_ef_sc_hd__decap_12
XTAP_TAPCELL_ROW_86_1182 VGND VPWR sky130_fd_sc_hd__tapvpwrvgnd_1
XFILLER_18_473 VGND VGND VPWR VPWR sky130_fd_sc_hd__decap_3
X_3723_ _4755_/Q _4756_/Q _3723_/C VGND VGND VPWR VPWR _3724_/B sky130_fd_sc_hd__and3_1
X_3654_ _3667_/B _3654_/B VGND VGND VPWR VPWR _3657_/A sky130_fd_sc_hd__nand2_1
XFILLER_106_209 VPWR VGND VPWR VGND sky130_ef_sc_hd__decap_12
X_2605_ _2605_/A _2605_/B VGND VGND VPWR VPWR _3396_/A sky130_fd_sc_hd__xor2_2
X_3585_ _3538_/A _3585_/B VGND VGND VPWR VPWR _3585_/Y sky130_fd_sc_hd__nand2b_1
XFILLER_0_509 VGND VGND VPWR VPWR sky130_fd_sc_hd__decap_8
X_2536_ _2432_/A _3813_/A2 _4473_/Q VGND VGND VPWR VPWR _4473_/D sky130_fd_sc_hd__mux2_1
X_2467_ _4452_/Q _4451_/Q _2467_/C VGND VGND VPWR VPWR _2468_/A sky130_fd_sc_hd__and3_1
X_4206_ _4206_/A1 _4203_/Y _4205_/Y _4206_/B1 hold229/X VGND VGND VPWR VPWR _4699_/D
+ sky130_fd_sc_hd__a32o_1
X_2398_ hold27/X _2408_/A2 _2408_/B1 _4499_/Q VGND VGND VPWR VPWR _4413_/D sky130_fd_sc_hd__a22o_1
XFILLER_95_181 VPWR VGND VPWR VGND sky130_ef_sc_hd__decap_12
XFILLER_28_248 VGND VGND VPWR VPWR sky130_fd_sc_hd__decap_4
X_4137_ hold170/X _4137_/A1 _4139_/S VGND VGND VPWR VPWR _4666_/D sky130_fd_sc_hd__mux2_1
XFILLER_56_557 VPWR VGND VPWR VGND sky130_ef_sc_hd__decap_12
XFILLER_71_505 VPWR VGND VPWR VGND sky130_ef_sc_hd__decap_12
X_4068_ _4113_/A _4068_/B _4113_/C _4068_/D VGND VGND VPWR VPWR _4076_/S sky130_fd_sc_hd__or4_4
X_3019_ _4542_/Q _3020_/B VGND VGND VPWR VPWR _3021_/A sky130_fd_sc_hd__and2_1
XFILLER_51_240 VGND VGND VPWR VPWR sky130_fd_sc_hd__decap_4
XFILLER_51_251 VPWR VGND VPWR VGND sky130_ef_sc_hd__decap_12
XFILLER_98_15 VPWR VGND VPWR VGND sky130_ef_sc_hd__decap_12
XFILLER_22_77 VGND VGND VPWR VPWR sky130_fd_sc_hd__decap_6
XFILLER_3_369 VGND VGND VPWR VPWR sky130_fd_sc_hd__fill_1
Xfanout150 fanout151/X VGND VGND VPWR VPWR fanout150/X sky130_fd_sc_hd__clkbuf_4
Xfanout161 fanout163/X VGND VGND VPWR VPWR fanout161/X sky130_fd_sc_hd__clkbuf_2
XFILLER_47_502 VGND VGND VPWR VPWR sky130_fd_sc_hd__fill_2
Xfanout172 fanout173/X VGND VGND VPWR VPWR fanout172/X sky130_fd_sc_hd__clkbuf_4
XFILLER_74_365 VGND VGND VPWR VPWR sky130_fd_sc_hd__fill_1
XFILLER_47_96 VGND VGND VPWR VPWR sky130_fd_sc_hd__fill_1
XTAP_TAPCELL_ROW_17_416 VGND VPWR sky130_fd_sc_hd__tapvpwrvgnd_1
XTAP_TAPCELL_ROW_45_725 VGND VPWR sky130_fd_sc_hd__tapvpwrvgnd_1
XFILLER_63_51 VGND VGND VPWR VPWR sky130_fd_sc_hd__decap_4
XFILLER_27_281 VGND VGND VPWR VPWR sky130_fd_sc_hd__fill_2
XFILLER_42_251 VGND VGND VPWR VPWR sky130_fd_sc_hd__fill_1
XFILLER_42_273 VGND VGND VPWR VPWR sky130_fd_sc_hd__fill_2
XFILLER_30_424 VGND VGND VPWR VPWR sky130_fd_sc_hd__decap_3
X_3370_ _3387_/B _3370_/B VGND VGND VPWR VPWR _3373_/A sky130_fd_sc_hd__and2_1
X_2321_ _4265_/A _4472_/Q _2320_/A _2275_/Y _2320_/X VGND VGND VPWR VPWR _2324_/B
+ sky130_fd_sc_hd__o221a_1
X_2252_ _2431_/A _2252_/B VGND VGND VPWR VPWR _4366_/D sky130_fd_sc_hd__nor2_1
XTAP_TAPCELL_ROW_88_1200 VGND VPWR sky130_fd_sc_hd__tapvpwrvgnd_1
XFILLER_26_3 VPWR VGND VPWR VGND sky130_ef_sc_hd__decap_12
XFILLER_65_332 VGND VGND VPWR VPWR sky130_fd_sc_hd__decap_4
X_2183_ _4444_/Q VGND VGND VPWR VPWR _2442_/A sky130_fd_sc_hd__inv_2
XFILLER_92_195 VGND VGND VPWR VPWR sky130_fd_sc_hd__fill_1
X_4755_ _4757_/CLK _4755_/D fanout137/X VGND VGND VPWR VPWR _4755_/Q sky130_fd_sc_hd__dfrtp_1
X_3706_ _3706_/A _3706_/B VGND VGND VPWR VPWR _3730_/A sky130_fd_sc_hd__nand2_1
XFILLER_107_529 VGND VGND VPWR VPWR sky130_fd_sc_hd__decap_3
X_4686_ _4727_/CLK _4686_/D fanout151/X VGND VGND VPWR VPWR _4686_/Q sky130_fd_sc_hd__dfrtp_2
X_3637_ _3637_/A _3637_/B _3733_/A VGND VGND VPWR VPWR _3638_/C sky130_fd_sc_hd__and3_1
X_3568_ _3597_/B _3568_/B VGND VGND VPWR VPWR _3572_/A sky130_fd_sc_hd__nand2_1
XFILLER_68_29 VPWR VGND VPWR VGND sky130_ef_sc_hd__decap_12
X_2519_ _2519_/A VGND VGND VPWR VPWR _2521_/B sky130_fd_sc_hd__inv_2
XFILLER_102_245 VGND VGND VPWR VPWR sky130_fd_sc_hd__decap_6
XFILLER_88_457 VPWR VGND VPWR VGND sky130_ef_sc_hd__decap_12
X_3499_ _3526_/B VGND VGND VPWR VPWR _3499_/Y sky130_fd_sc_hd__inv_2
XFILLER_102_289 VPWR VGND VPWR VGND sky130_ef_sc_hd__decap_12
XFILLER_71_302 VGND VGND VPWR VPWR sky130_fd_sc_hd__decap_4
XFILLER_17_55 VGND VGND VPWR VPWR sky130_fd_sc_hd__fill_1
XFILLER_71_335 VGND VGND VPWR VPWR sky130_fd_sc_hd__fill_1
XFILLER_17_77 VGND VGND VPWR VPWR sky130_fd_sc_hd__decap_3
XFILLER_24_240 VPWR VGND VPWR VGND sky130_ef_sc_hd__decap_12
XFILLER_52_560 VPWR VGND VPWR VGND sky130_ef_sc_hd__decap_12
XTAP_TAPCELL_ROW_104_1377 VGND VPWR sky130_fd_sc_hd__tapvpwrvgnd_1
XFILLER_8_417 VGND VGND VPWR VPWR sky130_fd_sc_hd__decap_3
XTAP_TAPCELL_ROW_22_474 VGND VPWR sky130_fd_sc_hd__tapvpwrvgnd_1
XTAP_TAPCELL_ROW_50_783 VGND VPWR sky130_fd_sc_hd__tapvpwrvgnd_1
XFILLER_3_111 VGND VGND VPWR VPWR sky130_fd_sc_hd__fill_1
XFILLER_79_424 VGND VGND VPWR VPWR sky130_fd_sc_hd__fill_1
XTAP_TAPCELL_ROW_72_1023 VGND VPWR sky130_fd_sc_hd__tapvpwrvgnd_1
Xhold6 hold6/A VGND VGND VPWR VPWR hold6/X sky130_fd_sc_hd__dlygate4sd3_1
XFILLER_35_538 VGND VGND VPWR VPWR sky130_fd_sc_hd__decap_8
XFILLER_47_387 VGND VGND VPWR VPWR sky130_fd_sc_hd__decap_4
XTAP_TAPCELL_ROW_58_872 VGND VPWR sky130_fd_sc_hd__tapvpwrvgnd_1
XFILLER_74_195 VGND VGND VPWR VPWR sky130_fd_sc_hd__fill_1
XFILLER_74_83 VGND VGND VPWR VPWR sky130_fd_sc_hd__fill_1
XTAP_TAPCELL_ROW_83_1141 VGND VPWR sky130_fd_sc_hd__tapvpwrvgnd_1
XFILLER_15_262 VPWR VGND VPWR VGND sky130_ef_sc_hd__decap_12
XFILLER_30_221 VGND VGND VPWR VPWR sky130_fd_sc_hd__decap_3
X_2870_ _3536_/A _2817_/B _2847_/B VGND VGND VPWR VPWR _2871_/B sky130_fd_sc_hd__a21oi_1
Xclkbuf_leaf_10_clk clkload2/A VGND VGND VPWR VPWR _4676_/CLK sky130_fd_sc_hd__clkbuf_8
X_4540_ _4542_/CLK _4540_/D fanout168/X VGND VGND VPWR VPWR _4540_/Q sky130_fd_sc_hd__dfrtp_4
X_4471_ _4770_/CLK _4471_/D fanout162/X VGND VGND VPWR VPWR _4471_/Q sky130_fd_sc_hd__dfrtp_1
X_3422_ _3422_/A _3422_/B VGND VGND VPWR VPWR _3423_/B sky130_fd_sc_hd__xnor2_1
XTAP_TAPCELL_ROW_94_1270 VGND VPWR sky130_fd_sc_hd__tapvpwrvgnd_1
X_3353_ _3353_/A _3353_/B _3353_/C VGND VGND VPWR VPWR _3355_/A sky130_fd_sc_hd__and3_1
X_3284_ _3281_/Y _3282_/X _3283_/X _3569_/S0 VGND VGND VPWR VPWR _3287_/B sky130_fd_sc_hd__o22ai_2
X_2304_ _4456_/Q _4700_/Q VGND VGND VPWR VPWR _2313_/A sky130_fd_sc_hd__and2b_1
XFILLER_85_449 VPWR VGND VPWR VGND sky130_ef_sc_hd__decap_12
X_2235_ hold6/X _2235_/B VGND VGND VPWR VPWR _4371_/D sky130_fd_sc_hd__and2_1
XFILLER_65_173 VGND VGND VPWR VPWR sky130_fd_sc_hd__fill_1
XFILLER_38_365 VGND VGND VPWR VPWR sky130_fd_sc_hd__decap_8
XFILLER_53_302 VPWR VGND VPWR VGND sky130_ef_sc_hd__decap_12
XFILLER_34_593 VGND VGND VPWR VPWR sky130_fd_sc_hd__fill_1
XPHY_EDGE_ROW_3_Right_3 VGND VGND VPWR VPWR sky130_fd_sc_hd__decap_3
X_2999_ _4509_/Q _2999_/B VGND VGND VPWR VPWR _3027_/B sky130_fd_sc_hd__xnor2_1
X_4738_ _4739_/CLK _4738_/D fanout129/X VGND VGND VPWR VPWR _4738_/Q sky130_fd_sc_hd__dfrtp_2
XFILLER_107_337 VPWR VGND VPWR VGND sky130_ef_sc_hd__decap_12
X_4669_ _4671_/CLK _4669_/D fanout133/X VGND VGND VPWR VPWR _4669_/Q sky130_fd_sc_hd__dfrtp_1
XFILLER_79_39 VPWR VGND VPWR VGND sky130_ef_sc_hd__decap_12
XFILLER_1_615 VGND VGND VPWR VPWR sky130_fd_sc_hd__fill_1
XFILLER_95_27 VPWR VGND VPWR VGND sky130_ef_sc_hd__decap_12
XFILLER_28_65 VPWR VGND VPWR VGND sky130_ef_sc_hd__decap_12
XFILLER_17_516 VGND VGND VPWR VPWR sky130_fd_sc_hd__decap_4
XFILLER_17_549 VGND VGND VPWR VPWR sky130_fd_sc_hd__decap_8
XTAP_TAPCELL_ROW_27_533 VGND VPWR sky130_fd_sc_hd__tapvpwrvgnd_1
XTAP_TAPCELL_ROW_55_842 VGND VPWR sky130_fd_sc_hd__tapvpwrvgnd_1
XFILLER_71_176 VGND VGND VPWR VPWR sky130_fd_sc_hd__fill_2
XFILLER_44_53 VPWR VGND VPWR VGND sky130_ef_sc_hd__decap_12
XFILLER_71_198 VPWR VGND VPWR VGND sky130_ef_sc_hd__decap_12
XFILLER_8_214 VGND VGND VPWR VPWR sky130_fd_sc_hd__decap_3
XFILLER_60_41 VPWR VGND VPWR VGND sky130_ef_sc_hd__decap_12
XFILLER_60_85 VPWR VGND VPWR VGND sky130_ef_sc_hd__decap_12
XFILLER_5_69 VPWR VGND VPWR VGND sky130_ef_sc_hd__decap_12
XFILLER_4_475 VGND VGND VPWR VPWR sky130_fd_sc_hd__fill_1
XFILLER_47_140 VGND VGND VPWR VPWR sky130_fd_sc_hd__fill_1
X_3971_ _3971_/A _3971_/B VGND VGND VPWR VPWR _3973_/B sky130_fd_sc_hd__xor2_1
X_2922_ _2922_/A _2922_/B _2922_/C VGND VGND VPWR VPWR _2924_/A sky130_fd_sc_hd__or3_1
XFILLER_93_3 VPWR VGND VPWR VGND sky130_ef_sc_hd__decap_12
XFILLER_31_541 VPWR VGND VPWR VGND sky130_ef_sc_hd__decap_12
X_2853_ _2878_/A _2853_/B VGND VGND VPWR VPWR _2855_/B sky130_fd_sc_hd__nand2_1
X_2784_ _3366_/B _3366_/C VGND VGND VPWR VPWR _3556_/A sky130_fd_sc_hd__and2_2
X_4523_ _4734_/CLK _4523_/D fanout146/X VGND VGND VPWR VPWR _4523_/Q sky130_fd_sc_hd__dfrtp_4
Xhold203 _2391_/X VGND VGND VPWR VPWR _4406_/D sky130_fd_sc_hd__dlygate4sd3_1
Xhold225 _4440_/Q VGND VGND VPWR VPWR _2235_/B sky130_fd_sc_hd__dlygate4sd3_1
Xhold214 _4603_/Q VGND VGND VPWR VPWR hold214/X sky130_fd_sc_hd__dlygate4sd3_1
XFILLER_104_307 VGND VGND VPWR VPWR sky130_fd_sc_hd__fill_1
Xhold269 _4431_/Q VGND VGND VPWR VPWR hold269/X sky130_fd_sc_hd__dlygate4sd3_1
Xhold236 _2420_/X VGND VGND VPWR VPWR _4435_/D sky130_fd_sc_hd__dlygate4sd3_1
Xhold258 _4454_/Q VGND VGND VPWR VPWR hold258/X sky130_fd_sc_hd__dlygate4sd3_1
X_4454_ _4699_/CLK _4454_/D fanout158/X VGND VGND VPWR VPWR _4454_/Q sky130_fd_sc_hd__dfrtp_1
Xhold247 _3996_/Y VGND VGND VPWR VPWR _4555_/D sky130_fd_sc_hd__dlygate4sd3_1
X_3405_ _3363_/X _3382_/X _3383_/Y VGND VGND VPWR VPWR _3407_/B sky130_fd_sc_hd__a21bo_1
X_4385_ _4538_/CLK _4385_/D fanout167/X VGND VGND VPWR VPWR hold26/A sky130_fd_sc_hd__dfrtp_1
XFILLER_105_15 VPWR VGND VPWR VGND sky130_ef_sc_hd__decap_12
X_3336_ _3337_/A _3337_/B VGND VGND VPWR VPWR _3336_/X sky130_fd_sc_hd__or2_1
XFILLER_100_513 VPWR VGND VPWR VGND sky130_ef_sc_hd__decap_12
XFILLER_100_557 VPWR VGND VPWR VGND sky130_ef_sc_hd__decap_12
X_3267_ _3544_/B _3267_/B VGND VGND VPWR VPWR _3267_/Y sky130_fd_sc_hd__nor2_2
XFILLER_85_279 VGND VGND VPWR VPWR sky130_fd_sc_hd__fill_1
X_3198_ _3198_/A _3198_/B VGND VGND VPWR VPWR _3204_/A sky130_fd_sc_hd__or2_1
XTAP_TAPCELL_ROW_69_989 VGND VPWR sky130_fd_sc_hd__tapvpwrvgnd_1
X_2218_ _4457_/Q VGND VGND VPWR VPWR _2218_/Y sky130_fd_sc_hd__inv_2
XFILLER_26_313 VGND VGND VPWR VPWR sky130_fd_sc_hd__fill_1
XFILLER_38_195 VGND VGND VPWR VPWR sky130_fd_sc_hd__fill_1
XFILLER_53_132 VGND VGND VPWR VPWR sky130_fd_sc_hd__fill_1
XFILLER_14_508 VGND VGND VPWR VPWR sky130_fd_sc_hd__decap_8
XTAP_TAPCELL_ROW_52_801 VGND VPWR sky130_fd_sc_hd__tapvpwrvgnd_1
XFILLER_81_485 VPWR VGND VPWR VGND sky130_ef_sc_hd__decap_12
XFILLER_41_327 VGND VGND VPWR VPWR sky130_fd_sc_hd__fill_1
XTAP_TAPCELL_ROW_101_1347 VGND VPWR sky130_fd_sc_hd__tapvpwrvgnd_1
XTAP_TAPCELL_ROW_32_580 VGND VPWR sky130_fd_sc_hd__tapvpwrvgnd_1
XPHY_EDGE_ROW_15_Left_123 VGND VGND VPWR VPWR sky130_fd_sc_hd__decap_3
XFILLER_107_145 VPWR VGND VPWR VGND sky130_ef_sc_hd__decap_12
XFILLER_1_401 VGND VGND VPWR VPWR sky130_fd_sc_hd__fill_1
XFILLER_30_77 VGND VGND VPWR VPWR sky130_fd_sc_hd__decap_6
XFILLER_89_541 VPWR VGND VPWR VGND sky130_ef_sc_hd__decap_12
XFILLER_103_373 VPWR VGND VPWR VGND sky130_ef_sc_hd__decap_12
XFILLER_89_585 VPWR VGND VPWR VGND sky130_ef_sc_hd__decap_12
XFILLER_76_224 VGND VGND VPWR VPWR sky130_fd_sc_hd__fill_2
XFILLER_49_416 VGND VGND VPWR VPWR sky130_fd_sc_hd__decap_8
XFILLER_64_419 VGND VGND VPWR VPWR sky130_fd_sc_hd__fill_1
XTAP_TAPCELL_ROW_4_272 VGND VPWR sky130_fd_sc_hd__tapvpwrvgnd_1
XPHY_EDGE_ROW_24_Left_132 VGND VGND VPWR VPWR sky130_fd_sc_hd__decap_3
XFILLER_45_600 VPWR VGND VPWR VGND sky130_ef_sc_hd__decap_12
XFILLER_17_335 VGND VGND VPWR VPWR sky130_fd_sc_hd__fill_1
XFILLER_57_482 VPWR VGND VPWR VGND sky130_ef_sc_hd__decap_12
XFILLER_72_474 VGND VGND VPWR VPWR sky130_fd_sc_hd__fill_2
XFILLER_72_441 VGND VGND VPWR VPWR sky130_fd_sc_hd__fill_1
XTAP_TAPCELL_ROW_80_1111 VGND VPWR sky130_fd_sc_hd__tapvpwrvgnd_1
XFILLER_60_625 VPWR VGND VPWR VGND sky130_ef_sc_hd__decap_12
XFILLER_71_51 VGND VGND VPWR VPWR sky130_fd_sc_hd__decap_4
XPHY_EDGE_ROW_33_Left_141 VGND VGND VPWR VPWR sky130_fd_sc_hd__decap_3
XFILLER_99_305 VPWR VGND VPWR VGND sky130_ef_sc_hd__decap_12
XTAP_TAPCELL_ROW_78_1095 VGND VPWR sky130_fd_sc_hd__tapvpwrvgnd_1
XFILLER_99_349 VPWR VGND VPWR VGND sky130_ef_sc_hd__decap_12
X_4170_ _4176_/C VGND VGND VPWR VPWR _4170_/Y sky130_fd_sc_hd__inv_2
X_3121_ _3068_/B _3071_/B _3094_/B _3066_/X VGND VGND VPWR VPWR _3122_/B sky130_fd_sc_hd__a211oi_1
XPHY_EDGE_ROW_42_Left_150 VGND VGND VPWR VPWR sky130_fd_sc_hd__decap_3
XFILLER_82_205 VGND VGND VPWR VPWR sky130_fd_sc_hd__fill_2
XFILLER_67_279 VGND VGND VPWR VPWR sky130_fd_sc_hd__fill_1
X_3052_ _4511_/Q _3053_/B VGND VGND VPWR VPWR _3052_/Y sky130_fd_sc_hd__nor2_1
XFILLER_82_227 VGND VGND VPWR VPWR sky130_fd_sc_hd__fill_2
XTAP_TAPCELL_ROW_66_959 VGND VPWR sky130_fd_sc_hd__tapvpwrvgnd_1
X_3954_ _3974_/B _3954_/B VGND VGND VPWR VPWR _3956_/C sky130_fd_sc_hd__nor2_1
X_3885_ _3885_/A _3885_/B VGND VGND VPWR VPWR _3887_/B sky130_fd_sc_hd__xnor2_1
X_2905_ _2905_/A _2905_/B VGND VGND VPWR VPWR _2963_/A sky130_fd_sc_hd__nand2_1
XFILLER_31_382 VGND VGND VPWR VPWR sky130_fd_sc_hd__fill_1
X_2836_ hold241/X _2983_/A2 _3633_/A _4339_/B2 VGND VGND VPWR VPWR _4502_/D sky130_fd_sc_hd__a22o_1
X_2767_ _2807_/A _2767_/B VGND VGND VPWR VPWR _2775_/A sky130_fd_sc_hd__xnor2_1
XFILLER_2_209 VGND VGND VPWR VPWR sky130_fd_sc_hd__decap_4
X_2698_ _4529_/Q _2698_/B _2698_/C VGND VGND VPWR VPWR _2698_/X sky130_fd_sc_hd__and3_1
X_4506_ _4513_/CLK _4506_/D fanout143/X VGND VGND VPWR VPWR _4506_/Q sky130_fd_sc_hd__dfrtp_1
X_4437_ _4481_/CLK _4437_/D fanout155/X VGND VGND VPWR VPWR _4437_/Q sky130_fd_sc_hd__dfrtp_1
XFILLER_86_533 VPWR VGND VPWR VGND sky130_ef_sc_hd__decap_12
XFILLER_76_29 VPWR VGND VPWR VGND sky130_ef_sc_hd__decap_12
X_4368_ _4726_/CLK _4368_/D fanout160/X VGND VGND VPWR VPWR _4368_/Q sky130_fd_sc_hd__dfrtp_1
XFILLER_100_321 VPWR VGND VPWR VGND sky130_ef_sc_hd__decap_12
X_3319_ _3300_/B _3318_/Y _3339_/B VGND VGND VPWR VPWR _3322_/A sky130_fd_sc_hd__o21ai_1
X_4299_ _4299_/A VGND VGND VPWR VPWR _4299_/Y sky130_fd_sc_hd__inv_2
XFILLER_100_365 VPWR VGND VPWR VGND sky130_ef_sc_hd__decap_12
XFILLER_73_205 VGND VGND VPWR VPWR sky130_fd_sc_hd__decap_6
XTAP_TAPCELL_ROW_1_242 VGND VPWR sky130_fd_sc_hd__tapvpwrvgnd_1
XFILLER_41_113 VGND VGND VPWR VPWR sky130_fd_sc_hd__decap_6
XFILLER_25_55 VGND VGND VPWR VPWR sky130_fd_sc_hd__fill_1
XFILLER_25_99 VGND VGND VPWR VPWR sky130_fd_sc_hd__fill_1
XFILLER_10_533 VGND VGND VPWR VPWR sky130_fd_sc_hd__decap_8
XFILLER_6_559 VPWR VGND VPWR VGND sky130_ef_sc_hd__decap_12
XTAP_TAPCELL_ROW_9_331 VGND VPWR sky130_fd_sc_hd__tapvpwrvgnd_1
XFILLER_1_253 VPWR VGND VPWR VGND sky130_ef_sc_hd__decap_12
XFILLER_2_15 VPWR VGND VPWR VGND sky130_ef_sc_hd__decap_12
XFILLER_103_181 VPWR VGND VPWR VGND sky130_ef_sc_hd__decap_12
XFILLER_92_525 VGND VGND VPWR VPWR sky130_fd_sc_hd__decap_6
XFILLER_92_569 VPWR VGND VPWR VGND sky130_ef_sc_hd__decap_12
XTAP_TAPCELL_ROW_63_929 VGND VPWR sky130_fd_sc_hd__tapvpwrvgnd_1
XFILLER_82_83 VGND VGND VPWR VPWR sky130_fd_sc_hd__fill_1
XFILLER_60_477 VPWR VGND VPWR VGND sky130_ef_sc_hd__decap_12
XFILLER_13_393 VGND VGND VPWR VPWR sky130_fd_sc_hd__decap_8
XTAP_TAPCELL_ROW_15_399 VGND VPWR sky130_fd_sc_hd__tapvpwrvgnd_1
X_3670_ _3670_/A VGND VGND VPWR VPWR _3720_/B sky130_fd_sc_hd__inv_2
X_2621_ _2619_/X _2621_/B VGND VGND VPWR VPWR _2623_/A sky130_fd_sc_hd__nand2b_2
X_2552_ _4477_/Q _2550_/C hold91/A VGND VGND VPWR VPWR _2552_/X sky130_fd_sc_hd__a21o_1
XFILLER_56_3 VPWR VGND VPWR VGND sky130_ef_sc_hd__decap_12
XFILLER_99_113 VPWR VGND VPWR VGND sky130_ef_sc_hd__decap_12
X_2483_ _2485_/B _2482_/Y hold284/X _2483_/B2 VGND VGND VPWR VPWR _4456_/D sky130_fd_sc_hd__a2bb2o_1
X_4222_ _4704_/Q _4222_/B VGND VGND VPWR VPWR _4225_/B sky130_fd_sc_hd__nand2_1
X_4153_ _4155_/A1 _4022_/X _4140_/D _4149_/Y hold76/X VGND VGND VPWR VPWR _4680_/D
+ sky130_fd_sc_hd__a32o_1
XFILLER_68_533 VPWR VGND VPWR VGND sky130_ef_sc_hd__decap_12
XFILLER_95_385 VGND VGND VPWR VPWR sky130_fd_sc_hd__decap_6
XFILLER_83_503 VGND VGND VPWR VPWR sky130_fd_sc_hd__fill_1
X_4084_ _4155_/A1 _4013_/Y _4139_/A1 _2352_/A hold51/X VGND VGND VPWR VPWR _4620_/D
+ sky130_fd_sc_hd__a32o_1
X_3104_ _3104_/A _3104_/B VGND VGND VPWR VPWR _3105_/C sky130_fd_sc_hd__nor2_1
X_3035_ hold256/X _3081_/A2 _3824_/A _4355_/B2 VGND VGND VPWR VPWR _4510_/D sky130_fd_sc_hd__a22o_1
XFILLER_102_27 VGND VGND VPWR VPWR sky130_fd_sc_hd__fill_1
XFILLER_51_400 VGND VGND VPWR VPWR sky130_fd_sc_hd__decap_8
XFILLER_63_293 VGND VGND VPWR VPWR sky130_fd_sc_hd__fill_1
XFILLER_51_455 VGND VGND VPWR VPWR sky130_fd_sc_hd__fill_1
X_3937_ _3956_/B _3936_/Y _4550_/Q _3979_/B2 VGND VGND VPWR VPWR _4550_/D sky130_fd_sc_hd__a2bb2o_1
X_3868_ _3869_/A _3868_/B VGND VGND VPWR VPWR _3889_/B sky130_fd_sc_hd__nor2_1
X_3799_ _3902_/A _3799_/B VGND VGND VPWR VPWR _3807_/A sky130_fd_sc_hd__xnor2_1
X_2819_ _2819_/A _2819_/B VGND VGND VPWR VPWR _2820_/C sky130_fd_sc_hd__or2_1
XFILLER_11_57 VPWR VGND VPWR VGND sky130_ef_sc_hd__decap_12
XFILLER_87_39 VPWR VGND VPWR VGND sky130_ef_sc_hd__decap_12
XTAP_TAPCELL_ROW_6_301 VGND VPWR sky130_fd_sc_hd__tapvpwrvgnd_1
XFILLER_86_363 VGND VGND VPWR VPWR sky130_fd_sc_hd__fill_1
XFILLER_46_205 VGND VGND VPWR VPWR sky130_fd_sc_hd__fill_1
XFILLER_100_195 VGND VGND VPWR VPWR sky130_fd_sc_hd__fill_1
XFILLER_74_525 VGND VGND VPWR VPWR sky130_fd_sc_hd__decap_6
XFILLER_46_216 VGND VGND VPWR VPWR sky130_fd_sc_hd__decap_4
XFILLER_74_569 VPWR VGND VPWR VGND sky130_ef_sc_hd__decap_12
XFILLER_27_430 VGND VGND VPWR VPWR sky130_fd_sc_hd__decap_4
XFILLER_15_614 VGND VGND VPWR VPWR sky130_fd_sc_hd__fill_2
XFILLER_36_65 VPWR VGND VPWR VGND sky130_ef_sc_hd__decap_12
XFILLER_54_260 VGND VGND VPWR VPWR sky130_fd_sc_hd__decap_6
XFILLER_52_53 VPWR VGND VPWR VGND sky130_ef_sc_hd__decap_12
XFILLER_52_75 VGND VGND VPWR VPWR sky130_fd_sc_hd__decap_8
XTAP_TAPCELL_ROW_12_369 VGND VPWR sky130_fd_sc_hd__tapvpwrvgnd_1
XFILLER_22_190 VGND VGND VPWR VPWR sky130_fd_sc_hd__decap_6
XTAP_TAPCELL_ROW_40_667 VGND VPWR sky130_fd_sc_hd__tapvpwrvgnd_1
XFILLER_97_617 VPWR VGND VPWR VGND sky130_ef_sc_hd__decap_12
XTAP_TAPCELL_ROW_75_1054 VGND VPWR sky130_fd_sc_hd__tapvpwrvgnd_1
XFILLER_65_503 VGND VGND VPWR VPWR sky130_fd_sc_hd__fill_1
XTAP_TAPCELL_ROW_48_756 VGND VPWR sky130_fd_sc_hd__tapvpwrvgnd_1
XFILLER_93_93 VPWR VGND VPWR VGND sky130_ef_sc_hd__decap_12
XTAP_TAPCELL_ROW_86_1183 VGND VPWR sky130_fd_sc_hd__tapvpwrvgnd_1
X_3722_ _4756_/Q _3755_/C VGND VGND VPWR VPWR _3756_/B sky130_fd_sc_hd__nor2_1
X_3653_ _4752_/Q _3652_/C _4753_/Q VGND VGND VPWR VPWR _3654_/B sky130_fd_sc_hd__o21ai_1
X_2604_ _4490_/Q _2576_/B _2588_/B _2586_/X VGND VGND VPWR VPWR _2605_/B sky130_fd_sc_hd__a31o_1
X_3584_ _3536_/A _3536_/B _3551_/B _4535_/Q VGND VGND VPWR VPWR _3584_/X sky130_fd_sc_hd__a22o_1
X_2535_ _2198_/Y _2535_/A2 _2532_/X _2534_/X VGND VGND VPWR VPWR _4472_/D sky130_fd_sc_hd__o31a_1
X_2466_ _2482_/B1 _2464_/Y _2465_/X _2483_/B2 _4451_/Q VGND VGND VPWR VPWR _4451_/D
+ sky130_fd_sc_hd__a32o_1
X_4205_ _4208_/B VGND VGND VPWR VPWR _4205_/Y sky130_fd_sc_hd__inv_2
X_2397_ hold18/X _2408_/A2 _2408_/B1 _4498_/Q VGND VGND VPWR VPWR hold19/A sky130_fd_sc_hd__a22o_1
X_4136_ hold116/X _4136_/A1 _4139_/S VGND VGND VPWR VPWR _4665_/D sky130_fd_sc_hd__mux2_1
XFILLER_95_193 VPWR VGND VPWR VGND sky130_ef_sc_hd__decap_12
X_4067_ _4139_/A1 hold152/X _4067_/S VGND VGND VPWR VPWR _4604_/D sky130_fd_sc_hd__mux2_1
XFILLER_56_569 VPWR VGND VPWR VGND sky130_ef_sc_hd__decap_12
XFILLER_71_517 VPWR VGND VPWR VGND sky130_ef_sc_hd__decap_12
X_3018_ _4538_/Q _4547_/Q VGND VGND VPWR VPWR _3020_/B sky130_fd_sc_hd__xor2_1
XFILLER_24_477 VPWR VGND VPWR VGND sky130_ef_sc_hd__decap_12
XFILLER_51_263 VPWR VGND VPWR VGND sky130_ef_sc_hd__decap_12
XFILLER_98_27 VGND VGND VPWR VPWR sky130_fd_sc_hd__fill_1
XFILLER_3_337 VPWR VGND VPWR VGND sky130_ef_sc_hd__decap_12
XFILLER_79_617 VPWR VGND VPWR VGND sky130_ef_sc_hd__decap_12
Xfanout140 fanout142/X VGND VGND VPWR VPWR fanout140/X sky130_fd_sc_hd__clkbuf_4
Xfanout151 fanout155/X VGND VGND VPWR VPWR fanout151/X sky130_fd_sc_hd__clkbuf_2
Xfanout173 input1/X VGND VGND VPWR VPWR fanout173/X sky130_fd_sc_hd__buf_4
Xfanout162 fanout163/X VGND VGND VPWR VPWR fanout162/X sky130_fd_sc_hd__clkbuf_4
XTAP_TAPCELL_ROW_17_417 VGND VPWR sky130_fd_sc_hd__tapvpwrvgnd_1
XTAP_TAPCELL_ROW_45_726 VGND VPWR sky130_fd_sc_hd__tapvpwrvgnd_1
XFILLER_103_81 VPWR VGND VPWR VGND sky130_ef_sc_hd__decap_12
XFILLER_15_477 VGND VGND VPWR VPWR sky130_fd_sc_hd__fill_1
XFILLER_15_499 VGND VGND VPWR VPWR sky130_fd_sc_hd__decap_4
XPHY_EDGE_ROW_7_Left_115 VGND VGND VPWR VPWR sky130_fd_sc_hd__decap_3
X_2320_ _2320_/A _2320_/B _2320_/C _2270_/X VGND VGND VPWR VPWR _2320_/X sky130_fd_sc_hd__or4b_1
XFILLER_97_447 VGND VGND VPWR VPWR sky130_fd_sc_hd__fill_1
XFILLER_88_93 VGND VGND VPWR VPWR sky130_fd_sc_hd__fill_2
XFILLER_85_609 VGND VGND VPWR VPWR sky130_fd_sc_hd__decap_6
XFILLER_2_370 VGND VGND VPWR VPWR sky130_fd_sc_hd__decap_4
X_2251_ _4365_/Q _2257_/B _2247_/X VGND VGND VPWR VPWR _2252_/B sky130_fd_sc_hd__a21oi_1
XFILLER_38_503 VGND VGND VPWR VPWR sky130_fd_sc_hd__fill_1
XTAP_TAPCELL_ROW_88_1201 VGND VPWR sky130_fd_sc_hd__tapvpwrvgnd_1
X_2182_ _4442_/Q VGND VGND VPWR VPWR _2182_/Y sky130_fd_sc_hd__inv_2
XFILLER_19_3 VPWR VGND VPWR VGND sky130_ef_sc_hd__decap_12
XFILLER_92_141 VGND VGND VPWR VPWR sky130_fd_sc_hd__decap_4
XFILLER_77_193 VGND VGND VPWR VPWR sky130_fd_sc_hd__decap_8
XFILLER_80_325 VGND VGND VPWR VPWR sky130_fd_sc_hd__fill_1
XFILLER_65_377 VGND VGND VPWR VPWR sky130_fd_sc_hd__fill_2
XFILLER_80_347 VGND VGND VPWR VPWR sky130_fd_sc_hd__decap_3
XFILLER_33_230 VPWR VGND VPWR VGND sky130_ef_sc_hd__decap_12
XFILLER_61_561 VPWR VGND VPWR VGND sky130_ef_sc_hd__decap_12
XFILLER_21_458 VGND VGND VPWR VPWR sky130_fd_sc_hd__decap_8
X_4754_ _4757_/CLK _4754_/D fanout136/X VGND VGND VPWR VPWR _4754_/Q sky130_fd_sc_hd__dfrtp_1
X_3705_ _3706_/A _3706_/B VGND VGND VPWR VPWR _3707_/A sky130_fd_sc_hd__or2_1
X_4685_ _4727_/CLK _4685_/D fanout151/X VGND VGND VPWR VPWR _4685_/Q sky130_fd_sc_hd__dfrtp_1
X_3636_ _3637_/A _3637_/B _3733_/A VGND VGND VPWR VPWR _3636_/X sky130_fd_sc_hd__a21o_1
X_3567_ _4750_/Q _3567_/B VGND VGND VPWR VPWR _3568_/B sky130_fd_sc_hd__nand2_1
X_2518_ _4467_/Q _4466_/Q _2518_/C VGND VGND VPWR VPWR _2519_/A sky130_fd_sc_hd__and3_1
X_3498_ _3592_/A _3498_/B VGND VGND VPWR VPWR _3526_/B sky130_fd_sc_hd__xnor2_2
XFILLER_88_469 VGND VGND VPWR VPWR sky130_fd_sc_hd__decap_6
X_2449_ _2449_/A _2449_/B VGND VGND VPWR VPWR _2449_/Y sky130_fd_sc_hd__nand2_1
XFILLER_84_29 VPWR VGND VPWR VGND sky130_ef_sc_hd__decap_12
X_4119_ hold105/X _4026_/X _4121_/S VGND VGND VPWR VPWR _4650_/D sky130_fd_sc_hd__mux2_1
XFILLER_29_569 VGND VGND VPWR VPWR sky130_fd_sc_hd__decap_3
XFILLER_16_219 VGND VGND VPWR VPWR sky130_fd_sc_hd__decap_8
XFILLER_24_230 VGND VGND VPWR VPWR sky130_fd_sc_hd__decap_6
XFILLER_52_572 VPWR VGND VPWR VGND sky130_ef_sc_hd__decap_12
XTAP_TAPCELL_ROW_104_1378 VGND VPWR sky130_fd_sc_hd__tapvpwrvgnd_1
XFILLER_12_447 VGND VGND VPWR VPWR sky130_fd_sc_hd__fill_1
XFILLER_33_55 VGND VGND VPWR VPWR sky130_fd_sc_hd__fill_1
XFILLER_33_77 VGND VGND VPWR VPWR sky130_fd_sc_hd__fill_2
XTAP_TAPCELL_ROW_22_475 VGND VPWR sky130_fd_sc_hd__tapvpwrvgnd_1
XTAP_TAPCELL_ROW_50_784 VGND VPWR sky130_fd_sc_hd__tapvpwrvgnd_1
XPHY_EDGE_ROW_89_Left_197 VGND VGND VPWR VPWR sky130_fd_sc_hd__decap_3
XTAP_TAPCELL_ROW_72_1024 VGND VPWR sky130_fd_sc_hd__tapvpwrvgnd_1
XFILLER_67_609 VGND VGND VPWR VPWR sky130_fd_sc_hd__decap_6
XFILLER_58_41 VPWR VGND VPWR VGND sky130_ef_sc_hd__decap_12
Xhold7 hold7/A VGND VGND VPWR VPWR hold7/X sky130_fd_sc_hd__dlygate4sd3_1
XFILLER_74_141 VPWR VGND VPWR VGND sky130_ef_sc_hd__decap_12
XFILLER_59_193 VGND VGND VPWR VPWR sky130_fd_sc_hd__decap_4
XFILLER_90_601 VPWR VGND VPWR VGND sky130_ef_sc_hd__decap_12
XTAP_TAPCELL_ROW_58_873 VGND VPWR sky130_fd_sc_hd__tapvpwrvgnd_1
XFILLER_74_185 VGND VGND VPWR VPWR sky130_fd_sc_hd__fill_2
XTAP_TAPCELL_ROW_83_1142 VGND VPWR sky130_fd_sc_hd__tapvpwrvgnd_1
XFILLER_70_380 VGND VGND VPWR VPWR sky130_fd_sc_hd__fill_1
XFILLER_15_274 VGND VGND VPWR VPWR sky130_fd_sc_hd__decap_6
XFILLER_90_83 VGND VGND VPWR VPWR sky130_fd_sc_hd__fill_1
X_4470_ _4770_/CLK _4470_/D fanout162/X VGND VGND VPWR VPWR hold61/A sky130_fd_sc_hd__dfrtp_1
XFILLER_99_81 VPWR VGND VPWR VGND sky130_ef_sc_hd__decap_12
X_3421_ _3398_/X _3401_/B _3397_/X VGND VGND VPWR VPWR _3422_/B sky130_fd_sc_hd__a21o_1
XTAP_TAPCELL_ROW_94_1271 VGND VPWR sky130_fd_sc_hd__tapvpwrvgnd_1
X_3352_ _3328_/Y _3331_/B _3327_/Y VGND VGND VPWR VPWR _3353_/C sky130_fd_sc_hd__a21o_1
X_2303_ _4696_/Q _2193_/Y _4695_/Q _2194_/Y _2302_/X VGND VGND VPWR VPWR _2310_/C
+ sky130_fd_sc_hd__a221o_1
X_3283_ _2224_/Y _2225_/Y _3283_/S VGND VGND VPWR VPWR _3283_/X sky130_fd_sc_hd__mux2_1
X_2234_ _4131_/B VGND VGND VPWR VPWR _4113_/C sky130_fd_sc_hd__inv_2
XFILLER_93_461 VPWR VGND VPWR VGND sky130_ef_sc_hd__decap_12
XFILLER_53_314 VPWR VGND VPWR VGND sky130_ef_sc_hd__decap_12
XFILLER_65_196 VGND VGND VPWR VPWR sky130_fd_sc_hd__decap_4
XFILLER_38_399 VPWR VGND VPWR VGND sky130_ef_sc_hd__decap_12
XFILLER_0_81 VGND VGND VPWR VPWR sky130_fd_sc_hd__decap_3
X_2998_ _4509_/Q _2999_/B VGND VGND VPWR VPWR _2998_/Y sky130_fd_sc_hd__nor2_1
X_4737_ _4737_/CLK _4737_/D fanout122/X VGND VGND VPWR VPWR _4737_/Q sky130_fd_sc_hd__dfrtp_1
XFILLER_107_305 VGND VGND VPWR VPWR sky130_fd_sc_hd__decap_3
X_4668_ clkload8/A _4668_/D fanout126/X VGND VGND VPWR VPWR hold93/A sky130_fd_sc_hd__dfrtp_1
XFILLER_107_349 VPWR VGND VPWR VGND sky130_ef_sc_hd__decap_12
X_3619_ _3620_/A _3620_/B VGND VGND VPWR VPWR _3672_/A sky130_fd_sc_hd__nand2_1
X_4599_ clkload7/A _4599_/D fanout124/X VGND VGND VPWR VPWR _4599_/Q sky130_fd_sc_hd__dfrtp_1
XFILLER_95_39 VPWR VGND VPWR VGND sky130_ef_sc_hd__decap_12
XFILLER_88_244 VGND VGND VPWR VPWR sky130_fd_sc_hd__decap_8
XFILLER_76_428 VGND VGND VPWR VPWR sky130_fd_sc_hd__decap_6
XFILLER_72_601 VPWR VGND VPWR VGND sky130_ef_sc_hd__decap_12
XFILLER_17_528 VGND VGND VPWR VPWR sky130_fd_sc_hd__fill_1
XFILLER_28_77 VGND VGND VPWR VPWR sky130_fd_sc_hd__decap_6
XTAP_TAPCELL_ROW_27_534 VGND VPWR sky130_fd_sc_hd__tapvpwrvgnd_1
XTAP_TAPCELL_ROW_55_832 VGND VPWR sky130_fd_sc_hd__tapvpwrvgnd_1
XFILLER_71_166 VGND VGND VPWR VPWR sky130_fd_sc_hd__fill_2
XFILLER_25_561 VGND VGND VPWR VPWR sky130_fd_sc_hd__fill_2
XFILLER_44_65 VPWR VGND VPWR VGND sky130_ef_sc_hd__decap_12
XFILLER_40_531 VGND VGND VPWR VPWR sky130_fd_sc_hd__fill_1
XFILLER_60_53 VPWR VGND VPWR VGND sky130_ef_sc_hd__decap_12
XPHY_EDGE_ROW_97_Left_205 VGND VGND VPWR VPWR sky130_fd_sc_hd__decap_3
XFILLER_60_97 VGND VGND VPWR VPWR sky130_fd_sc_hd__decap_4
XFILLER_5_15 VPWR VGND VPWR VGND sky130_ef_sc_hd__decap_12
XFILLER_4_421 VGND VGND VPWR VPWR sky130_fd_sc_hd__decap_6
XFILLER_69_51 VGND VGND VPWR VPWR sky130_fd_sc_hd__decap_4
XFILLER_4_498 VGND VGND VPWR VPWR sky130_fd_sc_hd__decap_4
XFILLER_79_277 VGND VGND VPWR VPWR sky130_fd_sc_hd__decap_3
XPHY_EDGE_ROW_13_Right_13 VGND VGND VPWR VPWR sky130_fd_sc_hd__decap_3
XFILLER_90_475 VGND VGND VPWR VPWR sky130_fd_sc_hd__fill_1
X_3970_ _3970_/A _3970_/B VGND VGND VPWR VPWR _3971_/B sky130_fd_sc_hd__xnor2_1
XFILLER_50_306 VGND VGND VPWR VPWR sky130_fd_sc_hd__fill_2
XFILLER_62_177 VGND VGND VPWR VPWR sky130_fd_sc_hd__decap_4
X_2921_ _2729_/B _2820_/Y _2822_/Y _2920_/A VGND VGND VPWR VPWR _2922_/C sky130_fd_sc_hd__a211oi_2
XFILLER_31_553 VGND VGND VPWR VPWR sky130_fd_sc_hd__decap_6
XFILLER_86_3 VPWR VGND VPWR VGND sky130_ef_sc_hd__decap_12
X_2852_ _4503_/Q _2852_/B VGND VGND VPWR VPWR _2853_/B sky130_fd_sc_hd__or2_1
XPHY_EDGE_ROW_22_Right_22 VGND VGND VPWR VPWR sky130_fd_sc_hd__decap_3
X_2783_ _2782_/A _2782_/C _2782_/B VGND VGND VPWR VPWR _3366_/C sky130_fd_sc_hd__a21o_1
X_4522_ _4527_/CLK _4522_/D fanout132/X VGND VGND VPWR VPWR _4522_/Q sky130_fd_sc_hd__dfrtp_4
Xhold204 _4584_/Q VGND VGND VPWR VPWR hold204/X sky130_fd_sc_hd__dlygate4sd3_1
Xhold226 _4514_/Q VGND VGND VPWR VPWR hold226/X sky130_fd_sc_hd__dlygate4sd3_1
X_4453_ _4699_/CLK _4453_/D fanout158/X VGND VGND VPWR VPWR _4453_/Q sky130_fd_sc_hd__dfrtp_1
Xhold215 _4702_/Q VGND VGND VPWR VPWR hold215/X sky130_fd_sc_hd__dlygate4sd3_1
Xhold259 _4766_/Q VGND VGND VPWR VPWR hold259/X sky130_fd_sc_hd__dlygate4sd3_1
Xhold237 _4426_/Q VGND VGND VPWR VPWR hold237/X sky130_fd_sc_hd__dlygate4sd3_1
Xhold248 _4448_/Q VGND VGND VPWR VPWR hold248/X sky130_fd_sc_hd__dlygate4sd3_1
X_3404_ _4528_/Q _3404_/B VGND VGND VPWR VPWR _3407_/A sky130_fd_sc_hd__xor2_1
XFILLER_98_531 VGND VGND VPWR VPWR sky130_fd_sc_hd__fill_1
X_4384_ _4481_/CLK hold3/X fanout152/X VGND VGND VPWR VPWR _4384_/Q sky130_fd_sc_hd__dfrtp_1
X_3335_ _3315_/A _3315_/B _3312_/X VGND VGND VPWR VPWR _3337_/B sky130_fd_sc_hd__a21o_1
XFILLER_58_406 VPWR VGND VPWR VGND sky130_ef_sc_hd__decap_12
XFILLER_105_27 VPWR VGND VPWR VGND sky130_ef_sc_hd__decap_12
XFILLER_100_525 VGND VGND VPWR VPWR sky130_fd_sc_hd__decap_6
XPHY_EDGE_ROW_31_Right_31 VGND VGND VPWR VPWR sky130_fd_sc_hd__decap_3
X_3266_ _4747_/Q _3543_/D _4748_/Q VGND VGND VPWR VPWR _3267_/B sky130_fd_sc_hd__o21a_1
XFILLER_100_569 VPWR VGND VPWR VGND sky130_ef_sc_hd__decap_12
X_2217_ _4701_/Q VGND VGND VPWR VPWR _2217_/Y sky130_fd_sc_hd__inv_2
XFILLER_38_130 VGND VGND VPWR VPWR sky130_fd_sc_hd__decap_8
X_3197_ _3197_/A _3197_/B _3197_/C VGND VGND VPWR VPWR _3198_/B sky130_fd_sc_hd__and3_1
XFILLER_66_461 VPWR VGND VPWR VGND sky130_ef_sc_hd__decap_12
XFILLER_54_601 VPWR VGND VPWR VGND sky130_ef_sc_hd__decap_12
XFILLER_81_420 VPWR VGND VPWR VGND sky130_ef_sc_hd__decap_12
XTAP_TAPCELL_ROW_52_802 VGND VPWR sky130_fd_sc_hd__tapvpwrvgnd_1
XFILLER_81_497 VGND VGND VPWR VPWR sky130_fd_sc_hd__decap_6
XFILLER_53_188 VGND VGND VPWR VPWR sky130_fd_sc_hd__decap_3
XTAP_TAPCELL_ROW_101_1348 VGND VPWR sky130_fd_sc_hd__tapvpwrvgnd_1
XPHY_EDGE_ROW_40_Right_40 VGND VGND VPWR VPWR sky130_fd_sc_hd__decap_3
XTAP_TAPCELL_ROW_32_581 VGND VPWR sky130_fd_sc_hd__tapvpwrvgnd_1
XTAP_TAPCELL_ROW_60_890 VGND VPWR sky130_fd_sc_hd__tapvpwrvgnd_1
XFILLER_107_113 VPWR VGND VPWR VGND sky130_ef_sc_hd__decap_12
XFILLER_107_157 VGND VGND VPWR VPWR sky130_fd_sc_hd__decap_8
XFILLER_89_553 VGND VGND VPWR VPWR sky130_fd_sc_hd__decap_6
XFILLER_103_385 VGND VGND VPWR VPWR sky130_fd_sc_hd__decap_6
XFILLER_89_597 VPWR VGND VPWR VGND sky130_ef_sc_hd__decap_12
XFILLER_49_428 VGND VGND VPWR VPWR sky130_fd_sc_hd__decap_4
XFILLER_91_217 VGND VGND VPWR VPWR sky130_fd_sc_hd__decap_6
XTAP_TAPCELL_ROW_4_273 VGND VPWR sky130_fd_sc_hd__tapvpwrvgnd_1
XFILLER_45_612 VGND VGND VPWR VPWR sky130_fd_sc_hd__decap_4
XFILLER_91_239 VPWR VGND VPWR VGND sky130_ef_sc_hd__decap_12
XFILLER_57_494 VGND VGND VPWR VPWR sky130_fd_sc_hd__decap_8
XFILLER_17_369 VGND VGND VPWR VPWR sky130_fd_sc_hd__fill_1
XFILLER_32_339 VGND VGND VPWR VPWR sky130_fd_sc_hd__fill_1
XTAP_TAPCELL_ROW_80_1112 VGND VPWR sky130_fd_sc_hd__tapvpwrvgnd_1
XFILLER_9_502 VGND VGND VPWR VPWR sky130_fd_sc_hd__fill_2
XFILLER_99_317 VPWR VGND VPWR VGND sky130_ef_sc_hd__decap_12
XTAP_TAPCELL_ROW_78_1085 VGND VPWR sky130_fd_sc_hd__tapvpwrvgnd_1
XFILLER_4_251 VGND VGND VPWR VPWR sky130_fd_sc_hd__fill_1
XTAP_TAPCELL_ROW_91_1230 VGND VPWR sky130_fd_sc_hd__tapvpwrvgnd_1
X_3120_ _3120_/A _3120_/B VGND VGND VPWR VPWR _3123_/A sky130_fd_sc_hd__nor2_1
XFILLER_67_225 VGND VGND VPWR VPWR sky130_fd_sc_hd__decap_4
XFILLER_67_247 VPWR VGND VPWR VGND sky130_ef_sc_hd__decap_12
X_3051_ _4511_/Q _3053_/B VGND VGND VPWR VPWR _3051_/Y sky130_fd_sc_hd__nand2_1
XFILLER_63_420 VGND VGND VPWR VPWR sky130_fd_sc_hd__fill_1
XFILLER_35_111 VGND VGND VPWR VPWR sky130_fd_sc_hd__fill_1
XFILLER_63_464 VPWR VGND VPWR VGND sky130_ef_sc_hd__decap_12
X_3953_ _4551_/Q _3953_/B VGND VGND VPWR VPWR _3954_/B sky130_fd_sc_hd__nor2_1
XFILLER_50_147 VGND VGND VPWR VPWR sky130_fd_sc_hd__decap_6
X_3884_ _3884_/A _3884_/B VGND VGND VPWR VPWR _3885_/B sky130_fd_sc_hd__xnor2_1
X_2904_ _4752_/Q _2904_/B VGND VGND VPWR VPWR _2905_/B sky130_fd_sc_hd__or2_1
X_2835_ _2835_/A _2835_/B VGND VGND VPWR VPWR _3633_/A sky130_fd_sc_hd__nor2_4
X_2766_ _2721_/A _2765_/B _2765_/A VGND VGND VPWR VPWR _2767_/B sky130_fd_sc_hd__o21ai_1
XFILLER_105_617 VPWR VGND VPWR VGND sky130_ef_sc_hd__decap_12
X_2697_ _4525_/Q _3536_/A VGND VGND VPWR VPWR _2698_/C sky130_fd_sc_hd__nand2_1
X_4505_ _4750_/CLK _4505_/D fanout131/X VGND VGND VPWR VPWR _4505_/Q sky130_fd_sc_hd__dfrtp_1
X_4436_ _4481_/CLK _4436_/D fanout152/X VGND VGND VPWR VPWR _4436_/Q sky130_fd_sc_hd__dfrtp_1
X_4367_ _4770_/CLK _4367_/D fanout160/X VGND VGND VPWR VPWR _4367_/Q sky130_fd_sc_hd__dfrtp_1
XFILLER_86_501 VPWR VGND VPWR VGND sky130_ef_sc_hd__decap_12
X_3318_ _4738_/Q _4739_/Q VGND VGND VPWR VPWR _3318_/Y sky130_fd_sc_hd__nand2_1
XFILLER_100_333 VPWR VGND VPWR VGND sky130_ef_sc_hd__decap_12
XFILLER_86_545 VPWR VGND VPWR VGND sky130_ef_sc_hd__decap_12
X_4298_ _4408_/Q hold11/A _4424_/Q _4432_/Q _4319_/S0 _2427_/B VGND VGND VPWR VPWR
+ _4299_/A sky130_fd_sc_hd__mux4_1
XFILLER_100_377 VPWR VGND VPWR VGND sky130_ef_sc_hd__decap_12
X_3249_ _3249_/A _3249_/B VGND VGND VPWR VPWR _3250_/B sky130_fd_sc_hd__xnor2_1
XFILLER_86_589 VPWR VGND VPWR VGND sky130_ef_sc_hd__decap_12
XFILLER_58_269 VGND VGND VPWR VPWR sky130_fd_sc_hd__fill_1
XTAP_TAPCELL_ROW_1_243 VGND VPWR sky130_fd_sc_hd__tapvpwrvgnd_1
XFILLER_92_29 VPWR VGND VPWR VGND sky130_ef_sc_hd__decap_12
XFILLER_66_291 VGND VGND VPWR VPWR sky130_fd_sc_hd__fill_1
XTAP_TAPCELL_ROW_37_640 VGND VPWR sky130_fd_sc_hd__tapvpwrvgnd_1
XFILLER_54_431 VGND VGND VPWR VPWR sky130_fd_sc_hd__decap_8
XFILLER_14_339 VGND VGND VPWR VPWR sky130_fd_sc_hd__decap_3
XFILLER_25_89 VGND VGND VPWR VPWR sky130_fd_sc_hd__fill_1
XFILLER_6_516 VGND VGND VPWR VPWR sky130_fd_sc_hd__fill_1
XFILLER_41_55 VGND VGND VPWR VPWR sky130_fd_sc_hd__fill_1
XTAP_TAPCELL_ROW_9_332 VGND VPWR sky130_fd_sc_hd__tapvpwrvgnd_1
XFILLER_96_309 VPWR VGND VPWR VGND sky130_ef_sc_hd__decap_12
XFILLER_1_265 VPWR VGND VPWR VGND sky130_ef_sc_hd__decap_12
XFILLER_103_193 VPWR VGND VPWR VGND sky130_ef_sc_hd__decap_12
XFILLER_2_27 VGND VGND VPWR VPWR sky130_fd_sc_hd__fill_1
XFILLER_49_225 VPWR VGND VPWR VGND sky130_ef_sc_hd__decap_12
XFILLER_66_41 VPWR VGND VPWR VGND sky130_ef_sc_hd__decap_12
XFILLER_37_409 VGND VGND VPWR VPWR sky130_fd_sc_hd__fill_2
XFILLER_66_85 VGND VGND VPWR VPWR sky130_fd_sc_hd__decap_3
XFILLER_64_228 VGND VGND VPWR VPWR sky130_fd_sc_hd__fill_1
XFILLER_18_612 VGND VGND VPWR VPWR sky130_fd_sc_hd__decap_3
XFILLER_72_261 VGND VGND VPWR VPWR sky130_fd_sc_hd__fill_1
XFILLER_60_445 VGND VGND VPWR VPWR sky130_fd_sc_hd__decap_8
XFILLER_60_489 VPWR VGND VPWR VGND sky130_ef_sc_hd__decap_12
XFILLER_20_309 VGND VGND VPWR VPWR sky130_fd_sc_hd__decap_6
X_2620_ _4493_/Q _2620_/B VGND VGND VPWR VPWR _2621_/B sky130_fd_sc_hd__or2_1
X_2551_ _2555_/B VGND VGND VPWR VPWR _2551_/Y sky130_fd_sc_hd__inv_2
XFILLER_99_125 VPWR VGND VPWR VGND sky130_ef_sc_hd__decap_12
X_2482_ _4456_/Q _2481_/B _2482_/B1 VGND VGND VPWR VPWR _2482_/Y sky130_fd_sc_hd__o21ai_1
XFILLER_99_169 VPWR VGND VPWR VGND sky130_ef_sc_hd__decap_12
XFILLER_87_309 VGND VGND VPWR VPWR sky130_fd_sc_hd__decap_6
X_4221_ _4704_/Q _4222_/B VGND VGND VPWR VPWR _4221_/X sky130_fd_sc_hd__or2_1
XFILLER_49_3 VPWR VGND VPWR VGND sky130_ef_sc_hd__decap_12
XFILLER_68_501 VPWR VGND VPWR VGND sky130_ef_sc_hd__decap_12
X_4152_ _4155_/A1 _4020_/X _4140_/D _4149_/Y hold70/X VGND VGND VPWR VPWR _4679_/D
+ sky130_fd_sc_hd__a32o_1
XFILLER_68_545 VPWR VGND VPWR VGND sky130_ef_sc_hd__decap_12
X_4083_ _4155_/A1 _4013_/Y _4138_/A1 _2352_/A hold54/X VGND VGND VPWR VPWR _4619_/D
+ sky130_fd_sc_hd__a32o_1
XFILLER_68_589 VPWR VGND VPWR VGND sky130_ef_sc_hd__decap_12
X_3103_ _4345_/B2 _3676_/B _3676_/C _4345_/A2 _4513_/Q VGND VGND VPWR VPWR _4513_/D
+ sky130_fd_sc_hd__a32o_1
X_3034_ _3054_/B _3034_/B VGND VGND VPWR VPWR _3824_/A sky130_fd_sc_hd__and2_2
XFILLER_83_559 VGND VGND VPWR VPWR sky130_fd_sc_hd__fill_1
XFILLER_24_604 VGND VGND VPWR VPWR sky130_fd_sc_hd__fill_1
XTAP_TAPCELL_ROW_34_610 VGND VPWR sky130_fd_sc_hd__tapvpwrvgnd_1
X_3936_ _3935_/A _3935_/B _3978_/A VGND VGND VPWR VPWR _3936_/Y sky130_fd_sc_hd__o21ai_1
X_3867_ _3889_/A _3868_/B VGND VGND VPWR VPWR _3869_/B sky130_fd_sc_hd__nor2_1
X_3798_ _3902_/A _3799_/B VGND VGND VPWR VPWR _3828_/A sky130_fd_sc_hd__or2_1
X_2818_ _2818_/A _2818_/B VGND VGND VPWR VPWR _2919_/A sky130_fd_sc_hd__nand2_1
X_2749_ _4745_/Q _2749_/B _2749_/C VGND VGND VPWR VPWR _2764_/B sky130_fd_sc_hd__nand3_1
XFILLER_11_69 VPWR VGND VPWR VGND sky130_ef_sc_hd__decap_12
XFILLER_105_447 VGND VGND VPWR VPWR sky130_fd_sc_hd__fill_1
XFILLER_78_309 VGND VGND VPWR VPWR sky130_fd_sc_hd__decap_4
XFILLER_59_501 VGND VGND VPWR VPWR sky130_fd_sc_hd__decap_3
XTAP_TAPCELL_ROW_6_302 VGND VPWR sky130_fd_sc_hd__tapvpwrvgnd_1
X_4419_ _4750_/CLK hold9/X fanout130/X VGND VGND VPWR VPWR hold8/A sky130_fd_sc_hd__dfrtp_1
XFILLER_100_141 VPWR VGND VPWR VGND sky130_ef_sc_hd__decap_12
XFILLER_46_228 VPWR VGND VPWR VGND sky130_ef_sc_hd__decap_12
XFILLER_82_581 VGND VGND VPWR VPWR sky130_fd_sc_hd__decap_6
XPHY_EDGE_ROW_61_Left_169 VGND VGND VPWR VPWR sky130_fd_sc_hd__decap_3
XFILLER_36_77 VGND VGND VPWR VPWR sky130_fd_sc_hd__decap_6
XFILLER_14_136 VGND VGND VPWR VPWR sky130_fd_sc_hd__decap_4
XFILLER_42_467 VGND VGND VPWR VPWR sky130_fd_sc_hd__decap_6
XFILLER_52_65 VGND VGND VPWR VPWR sky130_fd_sc_hd__decap_3
XTAP_TAPCELL_ROW_12_359 VGND VPWR sky130_fd_sc_hd__tapvpwrvgnd_1
XTAP_TAPCELL_ROW_40_668 VGND VPWR sky130_fd_sc_hd__tapvpwrvgnd_1
XPHY_EDGE_ROW_70_Left_178 VGND VGND VPWR VPWR sky130_fd_sc_hd__decap_3
XTAP_TAPCELL_ROW_75_1055 VGND VPWR sky130_fd_sc_hd__tapvpwrvgnd_1
XFILLER_2_530 VGND VGND VPWR VPWR sky130_fd_sc_hd__fill_2
XFILLER_97_629 VGND VGND VPWR VPWR sky130_fd_sc_hd__decap_8
XFILLER_96_139 VGND VGND VPWR VPWR sky130_fd_sc_hd__fill_1
XFILLER_89_191 VPWR VGND VPWR VGND sky130_ef_sc_hd__decap_12
XFILLER_77_51 VGND VGND VPWR VPWR sky130_fd_sc_hd__decap_4
XFILLER_65_559 VGND VGND VPWR VPWR sky130_fd_sc_hd__fill_1
XTAP_TAPCELL_ROW_48_757 VGND VPWR sky130_fd_sc_hd__tapvpwrvgnd_1
XTAP_TAPCELL_ROW_86_1173 VGND VPWR sky130_fd_sc_hd__tapvpwrvgnd_1
XFILLER_45_272 VGND VGND VPWR VPWR sky130_fd_sc_hd__fill_1
XFILLER_52_209 VPWR VGND VPWR VGND sky130_ef_sc_hd__decap_12
XFILLER_33_434 VPWR VGND VPWR VGND sky130_ef_sc_hd__decap_12
XFILLER_60_253 VPWR VGND VPWR VGND sky130_ef_sc_hd__decap_12
X_4770_ _4770_/CLK _4770_/D fanout162/X VGND VGND VPWR VPWR _4770_/Q sky130_fd_sc_hd__dfrtp_1
X_3721_ _3651_/B _3672_/X _3720_/C _3656_/Y _3674_/A VGND VGND VPWR VPWR _3730_/C
+ sky130_fd_sc_hd__a2111o_1
XFILLER_9_173 VGND VGND VPWR VPWR sky130_fd_sc_hd__fill_1
X_3652_ _4752_/Q _4753_/Q _3652_/C VGND VGND VPWR VPWR _3667_/B sky130_fd_sc_hd__or3_1
XFILLER_9_195 VPWR VGND VPWR VGND sky130_ef_sc_hd__decap_12
X_2603_ _4492_/Q _2603_/B VGND VGND VPWR VPWR _2605_/A sky130_fd_sc_hd__xor2_2
X_3583_ _3583_/A _3583_/B VGND VGND VPWR VPWR _3588_/A sky130_fd_sc_hd__nand2_1
X_2534_ _4471_/Q _2534_/A2 _2531_/B _4472_/Q VGND VGND VPWR VPWR _2534_/X sky130_fd_sc_hd__a31o_1
X_2465_ _4451_/Q _2467_/C VGND VGND VPWR VPWR _2465_/X sky130_fd_sc_hd__or2_1
X_4204_ _4204_/A _4204_/B VGND VGND VPWR VPWR _4208_/B sky130_fd_sc_hd__nor2_1
X_2396_ hold39/X _2408_/A2 _2408_/B1 _4497_/Q VGND VGND VPWR VPWR hold40/A sky130_fd_sc_hd__a22o_1
XFILLER_3_81 VPWR VGND VPWR VGND sky130_ef_sc_hd__decap_12
X_4135_ hold136/X _4135_/A1 _4139_/S VGND VGND VPWR VPWR _4664_/D sky130_fd_sc_hd__mux2_1
XFILLER_95_161 VGND VGND VPWR VPWR sky130_fd_sc_hd__decap_6
XFILLER_28_228 VGND VGND VPWR VPWR sky130_fd_sc_hd__fill_2
X_4066_ _4138_/A1 hold214/X _4067_/S VGND VGND VPWR VPWR _4603_/D sky130_fd_sc_hd__mux2_1
XFILLER_71_529 VPWR VGND VPWR VGND sky130_ef_sc_hd__decap_12
X_3017_ _2924_/A _3014_/X _3015_/X _3016_/X VGND VGND VPWR VPWR _3022_/A sky130_fd_sc_hd__o211ai_2
XFILLER_64_581 VGND VGND VPWR VPWR sky130_fd_sc_hd__decap_6
XFILLER_24_489 VGND VGND VPWR VPWR sky130_fd_sc_hd__decap_4
XFILLER_51_275 VGND VGND VPWR VPWR sky130_fd_sc_hd__decap_4
XFILLER_51_297 VGND VGND VPWR VPWR sky130_fd_sc_hd__decap_3
X_3919_ _3918_/A _3918_/B _3920_/A VGND VGND VPWR VPWR _3943_/B sky130_fd_sc_hd__a21bo_1
XFILLER_11_139 VPWR VGND VPWR VGND sky130_ef_sc_hd__decap_12
XFILLER_3_305 VGND VGND VPWR VPWR sky130_fd_sc_hd__decap_3
XFILLER_3_316 VPWR VGND VPWR VGND sky130_ef_sc_hd__decap_12
XFILLER_3_349 VGND VGND VPWR VPWR sky130_fd_sc_hd__decap_3
XFILLER_79_629 VGND VGND VPWR VPWR sky130_fd_sc_hd__decap_8
XFILLER_78_117 VGND VGND VPWR VPWR sky130_fd_sc_hd__decap_3
Xfanout130 fanout131/X VGND VGND VPWR VPWR fanout130/X sky130_fd_sc_hd__clkbuf_4
Xfanout141 fanout142/X VGND VGND VPWR VPWR fanout141/X sky130_fd_sc_hd__clkbuf_4
Xfanout163 fanout166/X VGND VGND VPWR VPWR fanout163/X sky130_fd_sc_hd__clkbuf_2
Xfanout152 fanout155/X VGND VGND VPWR VPWR fanout152/X sky130_fd_sc_hd__clkbuf_4
XFILLER_101_461 VPWR VGND VPWR VGND sky130_ef_sc_hd__decap_12
XFILLER_19_217 VGND VGND VPWR VPWR sky130_fd_sc_hd__decap_6
XFILLER_47_515 VGND VGND VPWR VPWR sky130_fd_sc_hd__decap_4
XTAP_TAPCELL_ROW_17_418 VGND VPWR sky130_fd_sc_hd__tapvpwrvgnd_1
XTAP_TAPCELL_ROW_45_727 VGND VPWR sky130_fd_sc_hd__tapvpwrvgnd_1
XFILLER_103_93 VPWR VGND VPWR VGND sky130_ef_sc_hd__decap_12
XPHY_EDGE_ROW_69_Right_69 VGND VGND VPWR VPWR sky130_fd_sc_hd__decap_3
XFILLER_63_75 VGND VGND VPWR VPWR sky130_fd_sc_hd__fill_1
XFILLER_8_15 VPWR VGND VPWR VGND sky130_ef_sc_hd__decap_12
XFILLER_15_489 VGND VGND VPWR VPWR sky130_fd_sc_hd__decap_6
XFILLER_10_194 VGND VGND VPWR VPWR sky130_fd_sc_hd__fill_2
XFILLER_6_154 VGND VGND VPWR VPWR sky130_fd_sc_hd__fill_2
XPHY_EDGE_ROW_78_Right_78 VGND VGND VPWR VPWR sky130_fd_sc_hd__decap_3
XFILLER_88_83 VGND VGND VPWR VPWR sky130_fd_sc_hd__fill_1
XFILLER_69_128 VGND VGND VPWR VPWR sky130_fd_sc_hd__decap_4
X_2250_ _2250_/A _2250_/B VGND VGND VPWR VPWR _2257_/B sky130_fd_sc_hd__nor2_1
XTAP_TAPCELL_ROW_88_1202 VGND VPWR sky130_fd_sc_hd__tapvpwrvgnd_1
X_2181_ _4441_/Q VGND VGND VPWR VPWR _2181_/Y sky130_fd_sc_hd__inv_2
XFILLER_18_250 VGND VGND VPWR VPWR sky130_fd_sc_hd__fill_2
XFILLER_92_197 VPWR VGND VPWR VGND sky130_ef_sc_hd__decap_12
XPHY_EDGE_ROW_87_Right_87 VGND VGND VPWR VPWR sky130_fd_sc_hd__decap_3
XFILLER_33_242 VPWR VGND VPWR VGND sky130_ef_sc_hd__decap_12
XFILLER_61_573 VPWR VGND VPWR VGND sky130_ef_sc_hd__decap_12
XFILLER_33_264 VGND VGND VPWR VPWR sky130_fd_sc_hd__fill_1
XTAP_TAPCELL_ROW_99_1320 VGND VPWR sky130_fd_sc_hd__tapvpwrvgnd_1
X_4753_ _4757_/CLK _4753_/D fanout136/X VGND VGND VPWR VPWR _4753_/Q sky130_fd_sc_hd__dfrtp_1
X_3704_ _4640_/Q _4576_/Q _4672_/Q _4608_/Q _3915_/S0 _3915_/S1 VGND VGND VPWR VPWR
+ _3706_/B sky130_fd_sc_hd__mux4_1
X_4684_ _4684_/CLK _4684_/D fanout142/X VGND VGND VPWR VPWR hold97/A sky130_fd_sc_hd__dfrtp_1
XPHY_EDGE_ROW_96_Right_96 VGND VGND VPWR VPWR sky130_fd_sc_hd__decap_3
X_3635_ _3637_/A _3637_/B _3733_/A VGND VGND VPWR VPWR _3638_/B sky130_fd_sc_hd__a21oi_1
X_3566_ _4750_/Q _3567_/B VGND VGND VPWR VPWR _3597_/B sky130_fd_sc_hd__or2_1
X_3497_ _3592_/A _3498_/B VGND VGND VPWR VPWR _3497_/Y sky130_fd_sc_hd__nand2_1
X_2517_ _4466_/Q _4465_/Q _2511_/B _4467_/Q VGND VGND VPWR VPWR _2517_/X sky130_fd_sc_hd__a31o_1
X_2448_ _2448_/A VGND VGND VPWR VPWR _2451_/B sky130_fd_sc_hd__inv_2
XFILLER_68_150 VGND VGND VPWR VPWR sky130_fd_sc_hd__decap_6
X_2379_ hold52/X _2379_/A2 _2379_/B1 _3791_/A VGND VGND VPWR VPWR _4394_/D sky130_fd_sc_hd__a22o_1
X_4118_ hold95/X _4024_/X _4121_/S VGND VGND VPWR VPWR _4649_/D sky130_fd_sc_hd__mux2_1
XFILLER_29_548 VGND VGND VPWR VPWR sky130_fd_sc_hd__fill_1
XFILLER_56_345 VGND VGND VPWR VPWR sky130_fd_sc_hd__decap_4
X_4049_ _4139_/A1 hold163/X _4049_/S VGND VGND VPWR VPWR _4588_/D sky130_fd_sc_hd__mux2_1
XFILLER_83_197 VGND VGND VPWR VPWR sky130_fd_sc_hd__decap_6
XFILLER_71_337 VPWR VGND VPWR VGND sky130_ef_sc_hd__decap_12
XFILLER_17_57 VPWR VGND VPWR VGND sky130_ef_sc_hd__decap_12
XFILLER_24_253 VPWR VGND VPWR VGND sky130_ef_sc_hd__decap_12
XTAP_TAPCELL_ROW_104_1379 VGND VPWR sky130_fd_sc_hd__tapvpwrvgnd_1
XFILLER_12_415 VGND VGND VPWR VPWR sky130_fd_sc_hd__decap_4
XFILLER_52_584 VGND VGND VPWR VPWR sky130_fd_sc_hd__decap_4
XTAP_TAPCELL_ROW_22_476 VGND VPWR sky130_fd_sc_hd__tapvpwrvgnd_1
XTAP_TAPCELL_ROW_50_785 VGND VPWR sky130_fd_sc_hd__tapvpwrvgnd_1
XFILLER_106_531 VGND VGND VPWR VPWR sky130_fd_sc_hd__fill_1
XTAP_TAPCELL_ROW_72_1025 VGND VPWR sky130_fd_sc_hd__tapvpwrvgnd_1
XFILLER_58_53 VPWR VGND VPWR VGND sky130_ef_sc_hd__decap_12
Xhold8 hold8/A VGND VGND VPWR VPWR hold8/X sky130_fd_sc_hd__dlygate4sd3_1
XFILLER_59_172 VGND VGND VPWR VPWR sky130_fd_sc_hd__fill_2
XFILLER_47_345 VGND VGND VPWR VPWR sky130_fd_sc_hd__fill_2
XFILLER_90_613 VPWR VGND VPWR VGND sky130_ef_sc_hd__decap_12
XFILLER_74_153 VGND VGND VPWR VPWR sky130_fd_sc_hd__fill_1
XFILLER_74_41 VPWR VGND VPWR VGND sky130_ef_sc_hd__decap_12
XTAP_TAPCELL_ROW_58_874 VGND VPWR sky130_fd_sc_hd__tapvpwrvgnd_1
XFILLER_74_85 VPWR VGND VPWR VGND sky130_ef_sc_hd__decap_12
XTAP_TAPCELL_ROW_83_1143 VGND VPWR sky130_fd_sc_hd__tapvpwrvgnd_1
XFILLER_15_297 VGND VGND VPWR VPWR sky130_fd_sc_hd__fill_1
XFILLER_30_289 VPWR VGND VPWR VGND sky130_ef_sc_hd__decap_12
X_3420_ _3418_/X _3420_/B VGND VGND VPWR VPWR _3422_/A sky130_fd_sc_hd__nand2b_1
XFILLER_99_93 VPWR VGND VPWR VGND sky130_ef_sc_hd__decap_12
XTAP_TAPCELL_ROW_94_1261 VGND VPWR sky130_fd_sc_hd__tapvpwrvgnd_1
X_3351_ _3351_/A _3351_/B _3351_/C VGND VGND VPWR VPWR _3353_/B sky130_fd_sc_hd__nand3_1
XFILLER_97_223 VGND VGND VPWR VPWR sky130_fd_sc_hd__fill_1
X_2302_ _4695_/Q _2194_/Y _2289_/Y _2298_/X _2301_/X VGND VGND VPWR VPWR _2302_/X
+ sky130_fd_sc_hd__o221a_1
XFILLER_31_3 VPWR VGND VPWR VGND sky130_ef_sc_hd__decap_12
X_3282_ _2223_/Y _3283_/S _3267_/B _3544_/B VGND VGND VPWR VPWR _3282_/X sky130_fd_sc_hd__a211o_1
X_2233_ _4361_/Q VGND VGND VPWR VPWR _4068_/B sky130_fd_sc_hd__inv_2
XFILLER_93_473 VPWR VGND VPWR VGND sky130_ef_sc_hd__decap_12
XFILLER_53_326 VGND VGND VPWR VPWR sky130_fd_sc_hd__decap_8
XFILLER_21_223 VGND VGND VPWR VPWR sky130_fd_sc_hd__fill_1
XFILLER_21_267 VGND VGND VPWR VPWR sky130_fd_sc_hd__decap_4
XFILLER_21_278 VGND VGND VPWR VPWR sky130_fd_sc_hd__fill_2
X_2997_ _2997_/A _2997_/B VGND VGND VPWR VPWR _2999_/B sky130_fd_sc_hd__xnor2_1
XFILLER_21_289 VGND VGND VPWR VPWR sky130_fd_sc_hd__fill_2
X_4736_ _4752_/CLK _4736_/D fanout136/X VGND VGND VPWR VPWR _4736_/Q sky130_fd_sc_hd__dfrtp_1
X_4667_ _4667_/CLK _4667_/D fanout125/X VGND VGND VPWR VPWR _4667_/Q sky130_fd_sc_hd__dfrtp_1
X_3618_ _4637_/Q _4573_/Q _4669_/Q _4605_/Q _3915_/S0 _3915_/S1 VGND VGND VPWR VPWR
+ _3620_/B sky130_fd_sc_hd__mux4_1
XFILLER_1_617 VPWR VGND VPWR VGND sky130_ef_sc_hd__decap_12
X_4598_ clkload7/A _4598_/D fanout127/X VGND VGND VPWR VPWR _4598_/Q sky130_fd_sc_hd__dfrtp_1
XFILLER_88_234 VGND VGND VPWR VPWR sky130_fd_sc_hd__fill_1
XFILLER_88_212 VGND VGND VPWR VPWR sky130_fd_sc_hd__decap_4
X_3549_ _3629_/B _3549_/B VGND VGND VPWR VPWR _3550_/B sky130_fd_sc_hd__xnor2_1
XFILLER_88_256 VGND VGND VPWR VPWR sky130_fd_sc_hd__decap_4
XFILLER_69_481 VPWR VGND VPWR VGND sky130_ef_sc_hd__decap_12
XFILLER_29_334 VGND VGND VPWR VPWR sky130_fd_sc_hd__fill_2
XFILLER_72_613 VPWR VGND VPWR VGND sky130_ef_sc_hd__decap_12
XFILLER_29_367 VGND VGND VPWR VPWR sky130_fd_sc_hd__fill_1
XTAP_TAPCELL_ROW_27_524 VGND VPWR sky130_fd_sc_hd__tapvpwrvgnd_1
XTAP_TAPCELL_ROW_55_833 VGND VPWR sky130_fd_sc_hd__tapvpwrvgnd_1
XFILLER_56_186 VGND VGND VPWR VPWR sky130_fd_sc_hd__decap_8
XFILLER_56_197 VGND VGND VPWR VPWR sky130_fd_sc_hd__decap_3
XFILLER_44_77 VGND VGND VPWR VPWR sky130_fd_sc_hd__decap_6
XFILLER_12_278 VGND VGND VPWR VPWR sky130_fd_sc_hd__decap_6
XFILLER_40_587 VGND VGND VPWR VPWR sky130_fd_sc_hd__fill_1
XFILLER_100_83 VGND VGND VPWR VPWR sky130_fd_sc_hd__fill_1
XFILLER_60_65 VPWR VGND VPWR VGND sky130_ef_sc_hd__decap_12
XFILLER_5_27 VPWR VGND VPWR VGND sky130_ef_sc_hd__decap_12
XFILLER_79_245 VPWR VGND VPWR VGND sky130_ef_sc_hd__decap_12
XFILLER_85_51 VGND VGND VPWR VPWR sky130_fd_sc_hd__decap_4
XFILLER_90_421 VPWR VGND VPWR VGND sky130_ef_sc_hd__decap_12
X_2920_ _2920_/A _2920_/B VGND VGND VPWR VPWR _2922_/B sky130_fd_sc_hd__nor2_1
XFILLER_50_329 VPWR VGND VPWR VGND sky130_ef_sc_hd__decap_12
XFILLER_16_595 VGND VGND VPWR VPWR sky130_fd_sc_hd__fill_1
X_2851_ _4503_/Q _2852_/B VGND VGND VPWR VPWR _2878_/A sky130_fd_sc_hd__nand2_1
XFILLER_79_3 VPWR VGND VPWR VGND sky130_ef_sc_hd__decap_12
X_2782_ _2782_/A _2782_/B _2782_/C VGND VGND VPWR VPWR _3366_/B sky130_fd_sc_hd__nand3_1
XFILLER_31_598 VGND VGND VPWR VPWR sky130_fd_sc_hd__decap_6
X_4521_ _4767_/CLK _4521_/D fanout144/X VGND VGND VPWR VPWR _4521_/Q sky130_fd_sc_hd__dfrtp_2
Xhold216 _4405_/Q VGND VGND VPWR VPWR hold216/X sky130_fd_sc_hd__dlygate4sd3_1
X_4452_ _4699_/CLK _4452_/D fanout158/X VGND VGND VPWR VPWR _4452_/Q sky130_fd_sc_hd__dfrtp_1
Xhold205 _4663_/Q VGND VGND VPWR VPWR hold205/X sky130_fd_sc_hd__dlygate4sd3_1
XFILLER_104_309 VPWR VGND VPWR VGND sky130_ef_sc_hd__decap_12
X_3403_ _4528_/Q _3404_/B VGND VGND VPWR VPWR _3403_/X sky130_fd_sc_hd__and2_1
Xhold227 _4590_/Q VGND VGND VPWR VPWR hold227/X sky130_fd_sc_hd__dlygate4sd3_1
Xhold238 _4410_/Q VGND VGND VPWR VPWR hold238/X sky130_fd_sc_hd__dlygate4sd3_1
Xhold249 _4463_/Q VGND VGND VPWR VPWR hold249/X sky130_fd_sc_hd__dlygate4sd3_1
X_4383_ _4481_/CLK _4383_/D fanout152/X VGND VGND VPWR VPWR hold25/A sky130_fd_sc_hd__dfrtp_1
X_3334_ _4525_/Q _3334_/B VGND VGND VPWR VPWR _3337_/A sky130_fd_sc_hd__xor2_1
XFILLER_105_39 VPWR VGND VPWR VGND sky130_ef_sc_hd__decap_12
XFILLER_98_587 VGND VGND VPWR VPWR sky130_fd_sc_hd__fill_1
XFILLER_85_215 VGND VGND VPWR VPWR sky130_fd_sc_hd__fill_2
X_3265_ _4747_/Q _4748_/Q _3543_/D VGND VGND VPWR VPWR _3544_/B sky130_fd_sc_hd__nor3_2
XFILLER_58_418 VGND VGND VPWR VPWR sky130_fd_sc_hd__fill_2
XFILLER_85_248 VPWR VGND VPWR VGND sky130_ef_sc_hd__decap_12
X_2216_ _4458_/Q VGND VGND VPWR VPWR _2488_/A sky130_fd_sc_hd__inv_2
X_3196_ _3197_/A _3197_/B _3197_/C VGND VGND VPWR VPWR _3198_/A sky130_fd_sc_hd__a21oi_1
XFILLER_66_473 VGND VGND VPWR VPWR sky130_fd_sc_hd__decap_3
XFILLER_54_613 VPWR VGND VPWR VGND sky130_ef_sc_hd__decap_12
XFILLER_93_281 VGND VGND VPWR VPWR sky130_fd_sc_hd__decap_3
XFILLER_81_432 VPWR VGND VPWR VGND sky130_ef_sc_hd__decap_12
XFILLER_26_326 VGND VGND VPWR VPWR sky130_fd_sc_hd__decap_8
XFILLER_38_197 VGND VGND VPWR VPWR sky130_fd_sc_hd__decap_8
XTAP_TAPCELL_ROW_52_803 VGND VPWR sky130_fd_sc_hd__tapvpwrvgnd_1
XTAP_TAPCELL_ROW_101_1338 VGND VPWR sky130_fd_sc_hd__tapvpwrvgnd_1
XFILLER_22_587 VGND VGND VPWR VPWR sky130_fd_sc_hd__fill_1
XTAP_TAPCELL_ROW_32_582 VGND VPWR sky130_fd_sc_hd__tapvpwrvgnd_1
XTAP_TAPCELL_ROW_60_891 VGND VPWR sky130_fd_sc_hd__tapvpwrvgnd_1
X_4719_ _4735_/CLK _4719_/D fanout148/X VGND VGND VPWR VPWR uo_out[0] sky130_fd_sc_hd__dfrtp_4
XFILLER_107_125 VPWR VGND VPWR VGND sky130_ef_sc_hd__decap_12
XFILLER_107_169 VPWR VGND VPWR VGND sky130_ef_sc_hd__decap_12
XFILLER_39_55 VGND VGND VPWR VPWR sky130_fd_sc_hd__fill_1
XFILLER_76_237 VGND VGND VPWR VPWR sky130_fd_sc_hd__decap_8
XTAP_TAPCELL_ROW_4_274 VGND VPWR sky130_fd_sc_hd__tapvpwrvgnd_1
XFILLER_72_421 VGND VGND VPWR VPWR sky130_fd_sc_hd__decap_3
XTAP_TAPCELL_ROW_68_980 VGND VPWR sky130_fd_sc_hd__tapvpwrvgnd_1
XFILLER_17_337 VGND VGND VPWR VPWR sky130_fd_sc_hd__decap_6
XFILLER_44_112 VGND VGND VPWR VPWR sky130_fd_sc_hd__fill_2
XPHY_EDGE_ROW_105_Right_105 VGND VGND VPWR VPWR sky130_fd_sc_hd__decap_3
XFILLER_32_307 VGND VGND VPWR VPWR sky130_fd_sc_hd__fill_1
XTAP_TAPCELL_ROW_80_1113 VGND VPWR sky130_fd_sc_hd__tapvpwrvgnd_1
XTAP_TAPCELL_ROW_78_1086 VGND VPWR sky130_fd_sc_hd__tapvpwrvgnd_1
XFILLER_99_329 VGND VGND VPWR VPWR sky130_fd_sc_hd__decap_6
XTAP_TAPCELL_ROW_91_1231 VGND VPWR sky130_fd_sc_hd__tapvpwrvgnd_1
XFILLER_67_204 VGND VGND VPWR VPWR sky130_fd_sc_hd__decap_8
XFILLER_96_83 VGND VGND VPWR VPWR sky130_fd_sc_hd__fill_1
X_3050_ _3050_/A _3050_/B VGND VGND VPWR VPWR _3053_/B sky130_fd_sc_hd__xnor2_4
XFILLER_67_259 VPWR VGND VPWR VGND sky130_ef_sc_hd__decap_12
XFILLER_75_281 VGND VGND VPWR VPWR sky130_fd_sc_hd__fill_1
XFILLER_90_251 VGND VGND VPWR VPWR sky130_fd_sc_hd__fill_1
XFILLER_63_476 VPWR VGND VPWR VGND sky130_ef_sc_hd__decap_12
XFILLER_35_167 VGND VGND VPWR VPWR sky130_fd_sc_hd__fill_1
XFILLER_35_189 VGND VGND VPWR VPWR sky130_fd_sc_hd__fill_2
X_3952_ _4551_/Q _3953_/B VGND VGND VPWR VPWR _3974_/B sky130_fd_sc_hd__and2_1
X_3883_ _3862_/A _3862_/B _3861_/B _3859_/X VGND VGND VPWR VPWR _3884_/B sky130_fd_sc_hd__a31oi_2
X_2903_ _4752_/Q _2904_/B VGND VGND VPWR VPWR _2905_/A sky130_fd_sc_hd__nand2_1
XFILLER_31_373 VGND VGND VPWR VPWR sky130_fd_sc_hd__fill_1
X_2834_ _2834_/A _2834_/B _2834_/C VGND VGND VPWR VPWR _2835_/B sky130_fd_sc_hd__and3_1
X_2765_ _2765_/A _2765_/B VGND VGND VPWR VPWR _2765_/Y sky130_fd_sc_hd__nand2_1
X_4504_ _4504_/CLK _4504_/D fanout131/X VGND VGND VPWR VPWR _4504_/Q sky130_fd_sc_hd__dfrtp_1
X_2696_ _4525_/Q _3536_/A VGND VGND VPWR VPWR _2698_/B sky130_fd_sc_hd__or2_1
XFILLER_105_629 VGND VGND VPWR VPWR sky130_fd_sc_hd__decap_8
X_4435_ _4513_/CLK _4435_/D fanout143/X VGND VGND VPWR VPWR _4435_/Q sky130_fd_sc_hd__dfrtp_1
XFILLER_104_139 VGND VGND VPWR VPWR sky130_fd_sc_hd__fill_1
X_4366_ _4726_/CLK _4366_/D fanout160/X VGND VGND VPWR VPWR hold58/A sky130_fd_sc_hd__dfrtp_1
XFILLER_100_301 VGND VGND VPWR VPWR sky130_fd_sc_hd__decap_6
XFILLER_86_513 VPWR VGND VPWR VGND sky130_ef_sc_hd__decap_12
X_3317_ _4524_/Q _3470_/B2 _3315_/Y _3316_/X VGND VGND VPWR VPWR _4524_/D sky130_fd_sc_hd__a22o_1
XFILLER_86_557 VPWR VGND VPWR VGND sky130_ef_sc_hd__decap_12
X_4297_ _4318_/A _4297_/B VGND VGND VPWR VPWR _4297_/Y sky130_fd_sc_hd__nor2_1
XFILLER_100_345 VPWR VGND VPWR VGND sky130_ef_sc_hd__decap_12
X_3248_ hold4/A _4521_/Q VGND VGND VPWR VPWR _3249_/B sky130_fd_sc_hd__xor2_1
XFILLER_100_389 VPWR VGND VPWR VGND sky130_ef_sc_hd__decap_12
X_3179_ _3179_/A _3179_/B _3179_/C VGND VGND VPWR VPWR _3180_/B sky130_fd_sc_hd__nand3_1
XFILLER_73_218 VGND VGND VPWR VPWR sky130_fd_sc_hd__fill_1
XTAP_TAPCELL_ROW_65_950 VGND VPWR sky130_fd_sc_hd__tapvpwrvgnd_1
XTAP_TAPCELL_ROW_1_244 VGND VPWR sky130_fd_sc_hd__tapvpwrvgnd_1
XFILLER_26_123 VGND VGND VPWR VPWR sky130_fd_sc_hd__decap_4
XTAP_TAPCELL_ROW_37_641 VGND VPWR sky130_fd_sc_hd__tapvpwrvgnd_1
XFILLER_25_57 VPWR VGND VPWR VGND sky130_ef_sc_hd__decap_12
XFILLER_10_513 VGND VGND VPWR VPWR sky130_fd_sc_hd__decap_8
XTAP_TAPCELL_ROW_9_333 VGND VPWR sky130_fd_sc_hd__tapvpwrvgnd_1
XFILLER_9_3 VPWR VGND VPWR VGND sky130_ef_sc_hd__decap_12
XFILLER_1_277 VGND VGND VPWR VPWR sky130_fd_sc_hd__decap_3
XFILLER_103_161 VGND VGND VPWR VPWR sky130_fd_sc_hd__decap_6
XFILLER_1_288 VGND VGND VPWR VPWR sky130_fd_sc_hd__decap_8
XFILLER_49_237 VGND VGND VPWR VPWR sky130_fd_sc_hd__decap_8
XFILLER_66_53 VPWR VGND VPWR VGND sky130_ef_sc_hd__decap_12
XFILLER_18_635 VGND VGND VPWR VPWR sky130_fd_sc_hd__fill_2
XFILLER_57_281 VPWR VGND VPWR VGND sky130_ef_sc_hd__decap_12
XFILLER_82_41 VPWR VGND VPWR VGND sky130_ef_sc_hd__decap_12
XFILLER_17_167 VGND VGND VPWR VPWR sky130_fd_sc_hd__fill_1
XFILLER_82_85 VGND VGND VPWR VPWR sky130_fd_sc_hd__decap_6
XFILLER_9_300 VPWR VGND VPWR VGND sky130_ef_sc_hd__decap_12
X_2550_ _4477_/Q hold91/A _2550_/C VGND VGND VPWR VPWR _2555_/B sky130_fd_sc_hd__and3_1
X_2481_ _4456_/Q _2481_/B VGND VGND VPWR VPWR _2485_/B sky130_fd_sc_hd__and2_1
XFILLER_99_137 VPWR VGND VPWR VGND sky130_ef_sc_hd__decap_12
X_4220_ _4222_/B _4219_/Y _4703_/Q _4238_/B1 VGND VGND VPWR VPWR _4703_/D sky130_fd_sc_hd__a2bb2o_1
XFILLER_68_513 VPWR VGND VPWR VGND sky130_ef_sc_hd__decap_12
X_4151_ _4149_/B _4018_/X _4140_/D _4149_/Y hold106/X VGND VGND VPWR VPWR _4678_/D
+ sky130_fd_sc_hd__a32o_1
XFILLER_68_557 VPWR VGND VPWR VGND sky130_ef_sc_hd__decap_12
X_4082_ _4155_/A1 _4013_/Y _4137_/A1 _2352_/A hold41/X VGND VGND VPWR VPWR _4618_/D
+ sky130_fd_sc_hd__a32o_1
XFILLER_83_505 VPWR VGND VPWR VGND sky130_ef_sc_hd__decap_12
X_3102_ _3676_/B _3676_/C VGND VGND VPWR VPWR _3902_/A sky130_fd_sc_hd__nand2_2
X_3033_ _3104_/A _3033_/B _3106_/A VGND VGND VPWR VPWR _3034_/B sky130_fd_sc_hd__nand3_1
XFILLER_36_421 VPWR VGND VPWR VGND sky130_ef_sc_hd__decap_12
XFILLER_102_29 VPWR VGND VPWR VGND sky130_ef_sc_hd__decap_12
XTAP_TAPCELL_ROW_34_611 VGND VPWR sky130_fd_sc_hd__tapvpwrvgnd_1
X_3935_ _3935_/A _3935_/B VGND VGND VPWR VPWR _3956_/B sky130_fd_sc_hd__and2_1
X_3866_ _4547_/Q _3866_/B VGND VGND VPWR VPWR _3868_/B sky130_fd_sc_hd__nor2_1
XTAP_TAPCELL_ROW_14_390 VGND VPWR sky130_fd_sc_hd__tapvpwrvgnd_1
X_3797_ _3797_/A _3922_/B VGND VGND VPWR VPWR _3799_/B sky130_fd_sc_hd__xor2_1
XFILLER_11_15 VPWR VGND VPWR VGND sky130_ef_sc_hd__decap_12
X_2817_ _3536_/A _2817_/B VGND VGND VPWR VPWR _2818_/B sky130_fd_sc_hd__or2_1
X_2748_ _2749_/B _2749_/C _4745_/Q VGND VGND VPWR VPWR _2765_/A sky130_fd_sc_hd__a21o_1
X_2679_ _4528_/Q _2679_/B VGND VGND VPWR VPWR _2680_/B sky130_fd_sc_hd__or2_1
X_4418_ _4504_/CLK hold16/X fanout154/X VGND VGND VPWR VPWR hold15/A sky130_fd_sc_hd__dfrtp_1
XTAP_TAPCELL_ROW_6_303 VGND VPWR sky130_fd_sc_hd__tapvpwrvgnd_1
X_4349_ _4761_/Q _4354_/A2 _3853_/A _4354_/B2 VGND VGND VPWR VPWR _4761_/D sky130_fd_sc_hd__a22o_1
XFILLER_86_365 VPWR VGND VPWR VGND sky130_ef_sc_hd__decap_12
XFILLER_100_153 VPWR VGND VPWR VGND sky130_ef_sc_hd__decap_12
XFILLER_86_387 VPWR VGND VPWR VGND sky130_ef_sc_hd__decap_12
XFILLER_100_197 VPWR VGND VPWR VGND sky130_ef_sc_hd__decap_12
XFILLER_39_281 VPWR VGND VPWR VGND sky130_ef_sc_hd__decap_12
XFILLER_27_476 VGND VGND VPWR VPWR sky130_fd_sc_hd__fill_2
XFILLER_54_240 VPWR VGND VPWR VGND sky130_ef_sc_hd__decap_12
XFILLER_14_115 VGND VGND VPWR VPWR sky130_fd_sc_hd__fill_1
XTAP_TAPCELL_ROW_40_669 VGND VPWR sky130_fd_sc_hd__tapvpwrvgnd_1
XFILLER_10_365 VGND VGND VPWR VPWR sky130_fd_sc_hd__decap_8
XFILLER_6_303 VGND VGND VPWR VPWR sky130_fd_sc_hd__fill_2
XTAP_TAPCELL_ROW_75_1056 VGND VPWR sky130_fd_sc_hd__tapvpwrvgnd_1
XFILLER_65_505 VPWR VGND VPWR VGND sky130_ef_sc_hd__decap_12
XFILLER_92_335 VGND VGND VPWR VPWR sky130_fd_sc_hd__decap_4
XFILLER_93_51 VGND VGND VPWR VPWR sky130_fd_sc_hd__decap_4
XFILLER_18_421 VGND VGND VPWR VPWR sky130_fd_sc_hd__decap_4
XTAP_TAPCELL_ROW_48_758 VGND VPWR sky130_fd_sc_hd__tapvpwrvgnd_1
XTAP_TAPCELL_ROW_86_1174 VGND VPWR sky130_fd_sc_hd__tapvpwrvgnd_1
XFILLER_33_446 VGND VGND VPWR VPWR sky130_fd_sc_hd__fill_2
XFILLER_60_265 VPWR VGND VPWR VGND sky130_ef_sc_hd__decap_12
X_3720_ _3720_/A _3720_/B _3720_/C VGND VGND VPWR VPWR _3730_/B sky130_fd_sc_hd__or3_1
Xclkbuf_leaf_40_clk _4459_/CLK VGND VGND VPWR VPWR _4721_/CLK sky130_fd_sc_hd__clkbuf_8
X_3651_ _3672_/A _3651_/B VGND VGND VPWR VPWR _3659_/A sky130_fd_sc_hd__nand2_1
XFILLER_61_3 VPWR VGND VPWR VGND sky130_ef_sc_hd__decap_12
X_2602_ _4492_/Q _2603_/B VGND VGND VPWR VPWR _2602_/X sky130_fd_sc_hd__and2_1
X_3582_ _3581_/B _3581_/C _3581_/A VGND VGND VPWR VPWR _3583_/B sky130_fd_sc_hd__o21ai_1
X_2533_ _4471_/Q _2535_/A2 _2531_/X _2532_/X VGND VGND VPWR VPWR _4471_/D sky130_fd_sc_hd__a22o_1
XFILLER_5_380 VGND VGND VPWR VPWR sky130_fd_sc_hd__fill_1
X_2464_ _4451_/Q _2467_/C VGND VGND VPWR VPWR _2464_/Y sky130_fd_sc_hd__nand2_1
X_4203_ _4204_/A _4204_/B VGND VGND VPWR VPWR _4203_/Y sky130_fd_sc_hd__nand2_1
X_2395_ hold238/X _2395_/A2 _2395_/B1 _4496_/Q VGND VGND VPWR VPWR _4410_/D sky130_fd_sc_hd__a22o_1
XFILLER_68_365 VPWR VGND VPWR VGND sky130_ef_sc_hd__decap_12
X_4134_ hold205/X _4134_/A1 _4139_/S VGND VGND VPWR VPWR _4663_/D sky130_fd_sc_hd__mux2_1
XFILLER_3_93 VPWR VGND VPWR VGND sky130_ef_sc_hd__decap_12
XFILLER_83_335 VGND VGND VPWR VPWR sky130_fd_sc_hd__fill_1
X_4065_ _4137_/A1 hold186/X _4067_/S VGND VGND VPWR VPWR _4602_/D sky130_fd_sc_hd__mux2_1
XFILLER_49_590 VGND VGND VPWR VPWR sky130_fd_sc_hd__fill_1
XFILLER_36_251 VGND VGND VPWR VPWR sky130_fd_sc_hd__fill_1
X_3016_ _2971_/A _2994_/B _2994_/A VGND VGND VPWR VPWR _3016_/X sky130_fd_sc_hd__o21ba_1
X_3918_ _3918_/A _3918_/B VGND VGND VPWR VPWR _3920_/B sky130_fd_sc_hd__nand2_1
Xclkbuf_leaf_31_clk clkload6/A VGND VGND VPWR VPWR _4481_/CLK sky130_fd_sc_hd__clkbuf_8
X_3849_ _4761_/Q _3849_/B VGND VGND VPWR VPWR _3849_/Y sky130_fd_sc_hd__nand2_1
XFILLER_98_29 VPWR VGND VPWR VGND sky130_ef_sc_hd__decap_12
XFILLER_105_223 VGND VGND VPWR VPWR sky130_fd_sc_hd__fill_1
XFILLER_3_328 VGND VGND VPWR VPWR sky130_fd_sc_hd__fill_1
Xfanout120 fanout128/X VGND VGND VPWR VPWR fanout120/X sky130_fd_sc_hd__clkbuf_4
Xfanout131 fanout132/X VGND VGND VPWR VPWR fanout131/X sky130_fd_sc_hd__buf_2
Xfanout142 fanout145/X VGND VGND VPWR VPWR fanout142/X sky130_fd_sc_hd__buf_2
Xfanout153 fanout155/X VGND VGND VPWR VPWR fanout153/X sky130_fd_sc_hd__clkbuf_4
Xfanout164 fanout166/X VGND VGND VPWR VPWR fanout164/X sky130_fd_sc_hd__clkbuf_4
XFILLER_47_505 VGND VGND VPWR VPWR sky130_fd_sc_hd__decap_4
XFILLER_101_473 VPWR VGND VPWR VGND sky130_ef_sc_hd__decap_12
XFILLER_47_55 VGND VGND VPWR VPWR sky130_fd_sc_hd__fill_1
XFILLER_74_335 VGND VGND VPWR VPWR sky130_fd_sc_hd__fill_2
XFILLER_15_402 VGND VGND VPWR VPWR sky130_fd_sc_hd__decap_4
XTAP_TAPCELL_ROW_17_419 VGND VPWR sky130_fd_sc_hd__tapvpwrvgnd_1
XTAP_TAPCELL_ROW_45_728 VGND VPWR sky130_fd_sc_hd__tapvpwrvgnd_1
XFILLER_15_413 VGND VGND VPWR VPWR sky130_fd_sc_hd__fill_1
XFILLER_15_424 VGND VGND VPWR VPWR sky130_fd_sc_hd__fill_1
Xclkbuf_leaf_22_clk clkload5/A VGND VGND VPWR VPWR _4542_/CLK sky130_fd_sc_hd__clkbuf_8
XFILLER_8_27 VGND VGND VPWR VPWR sky130_fd_sc_hd__fill_1
XFILLER_6_144 VGND VGND VPWR VPWR sky130_fd_sc_hd__fill_1
XFILLER_6_177 VGND VGND VPWR VPWR sky130_fd_sc_hd__fill_1
XFILLER_97_405 VPWR VGND VPWR VGND sky130_ef_sc_hd__decap_12
XFILLER_97_449 VPWR VGND VPWR VGND sky130_ef_sc_hd__decap_12
X_2180_ _4367_/Q VGND VGND VPWR VPWR _2354_/A sky130_fd_sc_hd__inv_2
XTAP_TAPCELL_ROW_88_1203 VGND VPWR sky130_fd_sc_hd__tapvpwrvgnd_1
XFILLER_61_541 VPWR VGND VPWR VGND sky130_ef_sc_hd__decap_12
XFILLER_33_254 VGND VGND VPWR VPWR sky130_fd_sc_hd__decap_3
XFILLER_61_585 VPWR VGND VPWR VGND sky130_ef_sc_hd__decap_12
XFILLER_33_276 VGND VGND VPWR VPWR sky130_fd_sc_hd__fill_1
Xclkbuf_leaf_13_clk clkload2/A VGND VGND VPWR VPWR _4679_/CLK sky130_fd_sc_hd__clkbuf_8
XFILLER_21_449 VGND VGND VPWR VPWR sky130_fd_sc_hd__decap_4
X_4752_ _4752_/CLK _4752_/D fanout136/X VGND VGND VPWR VPWR _4752_/Q sky130_fd_sc_hd__dfrtp_2
XTAP_TAPCELL_ROW_99_1321 VGND VPWR sky130_fd_sc_hd__tapvpwrvgnd_1
X_4683_ _4684_/CLK _4683_/D fanout142/X VGND VGND VPWR VPWR hold74/A sky130_fd_sc_hd__dfrtp_1
X_3703_ _3755_/C _3703_/B VGND VGND VPWR VPWR _3706_/A sky130_fd_sc_hd__nor2_1
X_3634_ _3634_/A _3634_/B VGND VGND VPWR VPWR _3733_/A sky130_fd_sc_hd__xnor2_1
X_3565_ _3565_/A _3565_/B _3565_/C VGND VGND VPWR VPWR _3580_/B sky130_fd_sc_hd__nand3_1
XFILLER_0_309 VPWR VGND VPWR VGND sky130_ef_sc_hd__decap_12
X_3496_ _3592_/A _3498_/B VGND VGND VPWR VPWR _3496_/Y sky130_fd_sc_hd__nor2_1
X_2516_ _2526_/A1 _2514_/Y _2515_/X _2526_/B1 hold281/X VGND VGND VPWR VPWR _4466_/D
+ sky130_fd_sc_hd__a32o_1
X_2447_ _2449_/A _2449_/B VGND VGND VPWR VPWR _2448_/A sky130_fd_sc_hd__nor2_1
XFILLER_29_516 VPWR VGND VPWR VGND sky130_ef_sc_hd__decap_12
X_2378_ hold13/X _2379_/A2 _2379_/B1 _4543_/Q VGND VGND VPWR VPWR _4393_/D sky130_fd_sc_hd__a22o_1
XFILLER_56_302 VGND VGND VPWR VPWR sky130_fd_sc_hd__decap_6
XFILLER_56_313 VGND VGND VPWR VPWR sky130_fd_sc_hd__fill_1
X_4117_ hold196/X _4022_/X _4121_/S VGND VGND VPWR VPWR _4648_/D sky130_fd_sc_hd__mux2_1
XFILLER_68_195 VGND VGND VPWR VPWR sky130_fd_sc_hd__fill_1
XFILLER_56_335 VGND VGND VPWR VPWR sky130_fd_sc_hd__fill_2
X_4048_ _4138_/A1 hold195/X _4049_/S VGND VGND VPWR VPWR _4587_/D sky130_fd_sc_hd__mux2_1
XFILLER_83_165 VGND VGND VPWR VPWR sky130_fd_sc_hd__decap_3
XFILLER_83_143 VGND VGND VPWR VPWR sky130_fd_sc_hd__decap_6
XFILLER_71_349 VGND VGND VPWR VPWR sky130_fd_sc_hd__decap_3
XFILLER_17_69 VGND VGND VPWR VPWR sky130_fd_sc_hd__decap_8
XFILLER_12_405 VGND VGND VPWR VPWR sky130_fd_sc_hd__fill_1
XFILLER_24_265 VGND VGND VPWR VPWR sky130_fd_sc_hd__decap_6
XFILLER_24_298 VGND VGND VPWR VPWR sky130_fd_sc_hd__decap_3
XFILLER_33_57 VPWR VGND VPWR VGND sky130_ef_sc_hd__decap_12
XTAP_TAPCELL_ROW_22_477 VGND VPWR sky130_fd_sc_hd__tapvpwrvgnd_1
XTAP_TAPCELL_ROW_50_786 VGND VPWR sky130_fd_sc_hd__tapvpwrvgnd_1
XFILLER_79_416 VGND VGND VPWR VPWR sky130_fd_sc_hd__decap_4
XFILLER_3_136 VGND VGND VPWR VPWR sky130_fd_sc_hd__decap_4
XFILLER_106_587 VGND VGND VPWR VPWR sky130_fd_sc_hd__fill_1
XFILLER_79_449 VPWR VGND VPWR VGND sky130_ef_sc_hd__decap_12
XTAP_TAPCELL_ROW_72_1026 VGND VPWR sky130_fd_sc_hd__tapvpwrvgnd_1
XFILLER_58_65 VPWR VGND VPWR VGND sky130_ef_sc_hd__decap_12
XFILLER_94_419 VGND VGND VPWR VPWR sky130_fd_sc_hd__fill_1
Xhold9 hold9/A VGND VGND VPWR VPWR hold9/X sky130_fd_sc_hd__dlygate4sd3_1
XFILLER_47_313 VGND VGND VPWR VPWR sky130_fd_sc_hd__fill_1
XFILLER_58_98 VGND VGND VPWR VPWR sky130_fd_sc_hd__fill_1
XFILLER_101_281 VPWR VGND VPWR VGND sky130_ef_sc_hd__decap_12
XFILLER_35_508 VGND VGND VPWR VPWR sky130_fd_sc_hd__decap_4
XFILLER_35_519 VGND VGND VPWR VPWR sky130_fd_sc_hd__decap_4
XTAP_TAPCELL_ROW_58_875 VGND VPWR sky130_fd_sc_hd__tapvpwrvgnd_1
XFILLER_90_625 VPWR VGND VPWR VGND sky130_ef_sc_hd__decap_12
XFILLER_74_53 VPWR VGND VPWR VGND sky130_ef_sc_hd__decap_12
XTAP_TAPCELL_ROW_83_1144 VGND VPWR sky130_fd_sc_hd__tapvpwrvgnd_1
XFILLER_74_97 VGND VGND VPWR VPWR sky130_fd_sc_hd__fill_2
XFILLER_55_390 VGND VGND VPWR VPWR sky130_fd_sc_hd__fill_2
XFILLER_90_41 VPWR VGND VPWR VGND sky130_ef_sc_hd__decap_12
XFILLER_70_393 VGND VGND VPWR VPWR sky130_fd_sc_hd__fill_1
XFILLER_90_85 VGND VGND VPWR VPWR sky130_fd_sc_hd__decap_4
XTAP_TAPCELL_ROW_94_1262 VGND VPWR sky130_fd_sc_hd__tapvpwrvgnd_1
X_3350_ _3351_/B _3351_/C _3351_/A VGND VGND VPWR VPWR _3353_/A sky130_fd_sc_hd__a21o_1
X_2301_ _2297_/X _2298_/X _2299_/X _2300_/X VGND VGND VPWR VPWR _2301_/X sky130_fd_sc_hd__a31o_1
X_3281_ _4558_/Q _3283_/S VGND VGND VPWR VPWR _3281_/Y sky130_fd_sc_hd__nor2_1
XFILLER_97_279 VGND VGND VPWR VPWR sky130_fd_sc_hd__fill_1
XFILLER_24_3 VPWR VGND VPWR VGND sky130_ef_sc_hd__decap_12
Xclkbuf_leaf_2_clk clkload0/A VGND VGND VPWR VPWR _4667_/CLK sky130_fd_sc_hd__clkbuf_8
X_2232_ _4131_/D VGND VGND VPWR VPWR _4041_/A sky130_fd_sc_hd__inv_2
XFILLER_93_441 VGND VGND VPWR VPWR sky130_fd_sc_hd__decap_6
XFILLER_65_121 VGND VGND VPWR VPWR sky130_fd_sc_hd__decap_4
XFILLER_65_154 VPWR VGND VPWR VGND sky130_ef_sc_hd__decap_12
XFILLER_93_485 VPWR VGND VPWR VGND sky130_ef_sc_hd__decap_12
XFILLER_65_187 VGND VGND VPWR VPWR sky130_fd_sc_hd__fill_2
XFILLER_19_582 VPWR VGND VPWR VGND sky130_ef_sc_hd__decap_12
XFILLER_61_360 VPWR VGND VPWR VGND sky130_ef_sc_hd__decap_12
XFILLER_9_81 VGND VGND VPWR VPWR sky130_fd_sc_hd__decap_8
X_4735_ _4735_/CLK _4735_/D fanout148/X VGND VGND VPWR VPWR _4735_/Q sky130_fd_sc_hd__dfrtp_4
X_2996_ _3013_/B _2996_/B VGND VGND VPWR VPWR _2997_/B sky130_fd_sc_hd__xor2_1
X_4666_ _4667_/CLK _4666_/D fanout125/X VGND VGND VPWR VPWR _4666_/Q sky130_fd_sc_hd__dfrtp_1
X_4597_ clkload7/A _4597_/D fanout124/X VGND VGND VPWR VPWR _4597_/Q sky130_fd_sc_hd__dfrtp_1
X_3617_ _4752_/Q _3652_/C VGND VGND VPWR VPWR _3620_/A sky130_fd_sc_hd__xnor2_1
X_3548_ _3575_/C _3548_/B VGND VGND VPWR VPWR _3549_/B sky130_fd_sc_hd__xnor2_1
XFILLER_1_629 VGND VGND VPWR VPWR sky130_fd_sc_hd__decap_8
XFILLER_0_139 VGND VGND VPWR VPWR sky130_fd_sc_hd__fill_1
X_3479_ _3479_/A _3479_/B VGND VGND VPWR VPWR _3480_/B sky130_fd_sc_hd__nand2_1
XFILLER_69_493 VGND VGND VPWR VPWR sky130_fd_sc_hd__decap_8
XFILLER_56_121 VPWR VGND VPWR VGND sky130_ef_sc_hd__decap_12
XFILLER_72_625 VPWR VGND VPWR VGND sky130_ef_sc_hd__decap_12
XFILLER_71_113 VGND VGND VPWR VPWR sky130_fd_sc_hd__decap_3
XTAP_TAPCELL_ROW_27_525 VGND VPWR sky130_fd_sc_hd__tapvpwrvgnd_1
XTAP_TAPCELL_ROW_55_834 VGND VPWR sky130_fd_sc_hd__tapvpwrvgnd_1
XFILLER_12_224 VPWR VGND VPWR VGND sky130_ef_sc_hd__decap_12
XFILLER_25_596 VPWR VGND VPWR VGND sky130_ef_sc_hd__decap_12
XFILLER_40_533 VGND VGND VPWR VPWR sky130_fd_sc_hd__decap_4
XFILLER_8_206 VGND VGND VPWR VPWR sky130_fd_sc_hd__decap_8
XFILLER_60_77 VGND VGND VPWR VPWR sky130_fd_sc_hd__decap_6
XFILLER_5_39 VPWR VGND VPWR VGND sky130_ef_sc_hd__decap_12
XFILLER_79_257 VPWR VGND VPWR VGND sky130_ef_sc_hd__decap_12
XFILLER_90_433 VPWR VGND VPWR VGND sky130_ef_sc_hd__decap_12
XFILLER_90_477 VPWR VGND VPWR VGND sky130_ef_sc_hd__decap_12
X_2850_ _2850_/A _2850_/B VGND VGND VPWR VPWR _2852_/B sky130_fd_sc_hd__xnor2_1
XFILLER_43_393 VPWR VGND VPWR VGND sky130_ef_sc_hd__decap_12
XFILLER_31_577 VGND VGND VPWR VPWR sky130_fd_sc_hd__decap_8
X_2781_ _4499_/Q _2755_/B _2758_/X VGND VGND VPWR VPWR _2781_/Y sky130_fd_sc_hd__a21oi_1
X_4520_ _4767_/CLK _4520_/D fanout144/X VGND VGND VPWR VPWR _4520_/Q sky130_fd_sc_hd__dfrtp_4
Xhold217 _2390_/X VGND VGND VPWR VPWR _4405_/D sky130_fd_sc_hd__dlygate4sd3_1
X_4451_ _4721_/CLK _4451_/D fanout158/X VGND VGND VPWR VPWR _4451_/Q sky130_fd_sc_hd__dfrtp_1
Xhold206 _4596_/Q VGND VGND VPWR VPWR hold206/X sky130_fd_sc_hd__dlygate4sd3_1
Xhold239 _4653_/Q VGND VGND VPWR VPWR hold239/X sky130_fd_sc_hd__dlygate4sd3_1
Xhold228 _4555_/Q VGND VGND VPWR VPWR _2241_/B sky130_fd_sc_hd__dlygate4sd3_1
X_3402_ _3402_/A _3402_/B VGND VGND VPWR VPWR _3404_/B sky130_fd_sc_hd__xnor2_1
XFILLER_98_533 VPWR VGND VPWR VGND sky130_ef_sc_hd__decap_12
X_4382_ _4532_/CLK _4382_/D fanout153/X VGND VGND VPWR VPWR hold20/A sky130_fd_sc_hd__dfrtp_1
X_3333_ _4525_/Q _3334_/B VGND VGND VPWR VPWR _3333_/X sky130_fd_sc_hd__and2_1
XPHY_EDGE_ROW_7_Right_7 VGND VGND VPWR VPWR sky130_fd_sc_hd__decap_3
X_3264_ _4743_/Q _4744_/Q _3409_/B _4746_/Q _4745_/Q VGND VGND VPWR VPWR _3543_/D
+ sky130_fd_sc_hd__o311a_2
XFILLER_39_611 VGND VGND VPWR VPWR sky130_fd_sc_hd__decap_4
XFILLER_85_238 VGND VGND VPWR VPWR sky130_fd_sc_hd__decap_6
X_2215_ _4702_/Q VGND VGND VPWR VPWR _4215_/A sky130_fd_sc_hd__inv_2
X_3195_ _4764_/Q _3195_/B VGND VGND VPWR VPWR _3197_/C sky130_fd_sc_hd__xnor2_1
XFILLER_54_625 VPWR VGND VPWR VGND sky130_ef_sc_hd__decap_12
XFILLER_81_444 VGND VGND VPWR VPWR sky130_fd_sc_hd__decap_4
XTAP_TAPCELL_ROW_52_804 VGND VPWR sky130_fd_sc_hd__tapvpwrvgnd_1
XTAP_TAPCELL_ROW_101_1339 VGND VPWR sky130_fd_sc_hd__tapvpwrvgnd_1
XFILLER_14_15 VPWR VGND VPWR VGND sky130_ef_sc_hd__decap_12
XFILLER_22_533 VGND VGND VPWR VPWR sky130_fd_sc_hd__fill_2
XTAP_TAPCELL_ROW_32_583 VGND VPWR sky130_fd_sc_hd__tapvpwrvgnd_1
X_2979_ _2878_/C _2930_/X _2931_/X _3028_/B _3028_/A VGND VGND VPWR VPWR _2981_/C
+ sky130_fd_sc_hd__a2111o_1
XTAP_TAPCELL_ROW_60_892 VGND VPWR sky130_fd_sc_hd__tapvpwrvgnd_1
X_4718_ _4727_/CLK _4718_/D fanout156/X VGND VGND VPWR VPWR _4718_/Q sky130_fd_sc_hd__dfrtp_4
XFILLER_107_137 VGND VGND VPWR VPWR sky130_fd_sc_hd__decap_3
X_4649_ _4764_/CLK _4649_/D fanout141/X VGND VGND VPWR VPWR hold95/A sky130_fd_sc_hd__dfrtp_1
XTAP_TAPCELL_ROW_4_275 VGND VPWR sky130_fd_sc_hd__tapvpwrvgnd_1
XFILLER_84_271 VGND VGND VPWR VPWR sky130_fd_sc_hd__fill_1
XTAP_TAPCELL_ROW_68_981 VGND VPWR sky130_fd_sc_hd__tapvpwrvgnd_1
XFILLER_29_165 VGND VGND VPWR VPWR sky130_fd_sc_hd__decap_3
XFILLER_44_135 VGND VGND VPWR VPWR sky130_fd_sc_hd__decap_4
XFILLER_55_55 VGND VGND VPWR VPWR sky130_fd_sc_hd__fill_1
XFILLER_72_477 VPWR VGND VPWR VGND sky130_ef_sc_hd__decap_12
XTAP_TAPCELL_ROW_80_1114 VGND VPWR sky130_fd_sc_hd__tapvpwrvgnd_1
XFILLER_40_385 VGND VGND VPWR VPWR sky130_fd_sc_hd__decap_4
XTAP_TAPCELL_ROW_78_1087 VGND VPWR sky130_fd_sc_hd__tapvpwrvgnd_1
XTAP_TAPCELL_ROW_91_1232 VGND VPWR sky130_fd_sc_hd__tapvpwrvgnd_1
XFILLER_95_503 VGND VGND VPWR VPWR sky130_fd_sc_hd__fill_1
XFILLER_63_400 VGND VGND VPWR VPWR sky130_fd_sc_hd__decap_6
XFILLER_35_113 VGND VGND VPWR VPWR sky130_fd_sc_hd__decap_6
XFILLER_48_474 VGND VGND VPWR VPWR sky130_fd_sc_hd__fill_2
XFILLER_63_455 VGND VGND VPWR VPWR sky130_fd_sc_hd__fill_1
XFILLER_90_274 VGND VGND VPWR VPWR sky130_fd_sc_hd__decap_4
X_3951_ _3951_/A _3951_/B VGND VGND VPWR VPWR _3953_/B sky130_fd_sc_hd__xnor2_2
XFILLER_63_488 VPWR VGND VPWR VGND sky130_ef_sc_hd__decap_12
XFILLER_51_617 VPWR VGND VPWR VGND sky130_ef_sc_hd__decap_12
X_2902_ _4573_/Q _4605_/Q _4637_/Q _4669_/Q _4324_/S _3174_/S1 VGND VGND VPWR VPWR
+ _2904_/B sky130_fd_sc_hd__mux4_1
XFILLER_91_3 VPWR VGND VPWR VGND sky130_ef_sc_hd__decap_12
X_3882_ _3882_/A _3882_/B VGND VGND VPWR VPWR _3884_/A sky130_fd_sc_hd__xnor2_1
X_2833_ _2834_/B _2834_/C _2834_/A VGND VGND VPWR VPWR _2835_/A sky130_fd_sc_hd__a21oi_2
X_2764_ _2764_/A _2764_/B VGND VGND VPWR VPWR _2765_/B sky130_fd_sc_hd__nand2_1
X_4503_ _4504_/CLK _4503_/D fanout131/X VGND VGND VPWR VPWR _4503_/Q sky130_fd_sc_hd__dfrtp_1
X_2695_ _2680_/B _2683_/B _2680_/A VGND VGND VPWR VPWR _2702_/A sky130_fd_sc_hd__a21boi_1
X_4434_ _4539_/CLK _4434_/D fanout169/X VGND VGND VPWR VPWR _4434_/Q sky130_fd_sc_hd__dfrtp_1
X_4365_ _4770_/CLK _4365_/D fanout162/X VGND VGND VPWR VPWR _4365_/Q sky130_fd_sc_hd__dfrtp_1
XFILLER_98_363 VGND VGND VPWR VPWR sky130_fd_sc_hd__fill_1
X_3316_ _3315_/A _3315_/B _3554_/B2 VGND VGND VPWR VPWR _3316_/X sky130_fd_sc_hd__o21a_1
XFILLER_86_525 VGND VGND VPWR VPWR sky130_fd_sc_hd__decap_6
X_4296_ hold33/A _4384_/Q hold31/A _4400_/Q _4319_/S0 _2427_/B VGND VGND VPWR VPWR
+ _4297_/B sky130_fd_sc_hd__mux4_1
XFILLER_58_238 VPWR VGND VPWR VGND sky130_ef_sc_hd__decap_12
XFILLER_100_357 VGND VGND VPWR VPWR sky130_fd_sc_hd__decap_6
X_3247_ _4767_/Q _4549_/Q VGND VGND VPWR VPWR _3249_/A sky130_fd_sc_hd__xor2_1
XFILLER_86_569 VPWR VGND VPWR VGND sky130_ef_sc_hd__decap_12
X_3178_ _3179_/A _3179_/B _3179_/C VGND VGND VPWR VPWR _3197_/B sky130_fd_sc_hd__a21o_1
XTAP_TAPCELL_ROW_65_951 VGND VPWR sky130_fd_sc_hd__tapvpwrvgnd_1
XTAP_TAPCELL_ROW_1_245 VGND VPWR sky130_fd_sc_hd__tapvpwrvgnd_1
XTAP_TAPCELL_ROW_37_642 VGND VPWR sky130_fd_sc_hd__tapvpwrvgnd_1
XFILLER_54_477 VPWR VGND VPWR VGND sky130_ef_sc_hd__decap_12
XFILLER_81_296 VGND VGND VPWR VPWR sky130_fd_sc_hd__fill_1
XFILLER_25_69 VPWR VGND VPWR VGND sky130_ef_sc_hd__decap_12
XFILLER_22_363 VGND VGND VPWR VPWR sky130_fd_sc_hd__fill_1
XFILLER_41_57 VPWR VGND VPWR VGND sky130_ef_sc_hd__decap_12
XTAP_TAPCELL_ROW_9_334 VGND VPWR sky130_fd_sc_hd__tapvpwrvgnd_1
XFILLER_89_330 VGND VGND VPWR VPWR sky130_fd_sc_hd__decap_6
XFILLER_77_503 VGND VGND VPWR VPWR sky130_fd_sc_hd__fill_1
XFILLER_2_29 VPWR VGND VPWR VGND sky130_ef_sc_hd__decap_12
XFILLER_106_83 VGND VGND VPWR VPWR sky130_fd_sc_hd__fill_1
XFILLER_66_65 VPWR VGND VPWR VGND sky130_ef_sc_hd__decap_12
XFILLER_45_400 VGND VGND VPWR VPWR sky130_fd_sc_hd__fill_2
XFILLER_57_260 VGND VGND VPWR VPWR sky130_fd_sc_hd__fill_1
XFILLER_17_113 VGND VGND VPWR VPWR sky130_fd_sc_hd__decap_4
XFILLER_57_293 VPWR VGND VPWR VGND sky130_ef_sc_hd__decap_12
XFILLER_33_617 VPWR VGND VPWR VGND sky130_ef_sc_hd__decap_12
XFILLER_82_53 VPWR VGND VPWR VGND sky130_ef_sc_hd__decap_12
XFILLER_9_334 VGND VGND VPWR VPWR sky130_fd_sc_hd__fill_2
XFILLER_9_312 VPWR VGND VPWR VGND sky130_ef_sc_hd__decap_12
XFILLER_99_105 VGND VGND VPWR VPWR sky130_fd_sc_hd__decap_6
X_2480_ _2486_/A1 _2477_/Y _2479_/Y _2486_/B1 hold285/X VGND VGND VPWR VPWR _4455_/D
+ sky130_fd_sc_hd__a32o_1
XFILLER_99_149 VPWR VGND VPWR VGND sky130_ef_sc_hd__decap_12
XFILLER_5_584 VPWR VGND VPWR VGND sky130_ef_sc_hd__decap_12
X_4150_ _4149_/B _4008_/X _4140_/D _4149_/Y hold83/X VGND VGND VPWR VPWR _4677_/D
+ sky130_fd_sc_hd__a32o_1
XFILLER_68_525 VGND VGND VPWR VPWR sky130_fd_sc_hd__decap_6
X_3101_ _3100_/A _3100_/B _3100_/C VGND VGND VPWR VPWR _3676_/C sky130_fd_sc_hd__a21o_1
X_4081_ _4155_/A1 _4013_/Y _4136_/A1 _2352_/A hold44/X VGND VGND VPWR VPWR _4617_/D
+ sky130_fd_sc_hd__a32o_1
XFILLER_68_569 VPWR VGND VPWR VGND sky130_ef_sc_hd__decap_12
XFILLER_83_517 VPWR VGND VPWR VGND sky130_ef_sc_hd__decap_12
XFILLER_55_208 VPWR VGND VPWR VGND sky130_ef_sc_hd__decap_12
X_3032_ _3033_/B _3106_/A _3104_/A VGND VGND VPWR VPWR _3054_/B sky130_fd_sc_hd__a21o_1
XFILLER_36_433 VPWR VGND VPWR VGND sky130_ef_sc_hd__decap_12
XFILLER_91_561 VPWR VGND VPWR VGND sky130_ef_sc_hd__decap_12
XTAP_TAPCELL_ROW_62_910 VGND VPWR sky130_fd_sc_hd__tapvpwrvgnd_1
XTAP_TAPCELL_ROW_34_601 VGND VPWR sky130_fd_sc_hd__tapvpwrvgnd_1
X_3934_ _3847_/B _3869_/B _3931_/Y _3933_/Y VGND VGND VPWR VPWR _3935_/B sky130_fd_sc_hd__a31o_1
X_3865_ _4547_/Q _3866_/B VGND VGND VPWR VPWR _3889_/A sky130_fd_sc_hd__and2_1
XTAP_TAPCELL_ROW_14_391 VGND VPWR sky130_fd_sc_hd__tapvpwrvgnd_1
X_2816_ _3536_/A _2817_/B VGND VGND VPWR VPWR _2818_/A sky130_fd_sc_hd__nand2_1
X_3796_ _3820_/A _3819_/A VGND VGND VPWR VPWR _3808_/A sky130_fd_sc_hd__nor2_1
XFILLER_11_27 VPWR VGND VPWR VGND sky130_ef_sc_hd__decap_12
X_2747_ _2747_/A _2747_/B VGND VGND VPWR VPWR _2749_/C sky130_fd_sc_hd__or2_1
XFILLER_105_405 VPWR VGND VPWR VGND sky130_ef_sc_hd__decap_12
X_2678_ _4528_/Q _2679_/B VGND VGND VPWR VPWR _2680_/A sky130_fd_sc_hd__nand2_1
XFILLER_105_449 VPWR VGND VPWR VGND sky130_ef_sc_hd__decap_12
X_4417_ _4533_/CLK hold24/X fanout154/X VGND VGND VPWR VPWR hold23/A sky130_fd_sc_hd__dfrtp_1
X_4348_ _4760_/Q _4354_/A2 _3817_/A _4354_/B2 VGND VGND VPWR VPWR _4760_/D sky130_fd_sc_hd__a22o_1
XFILLER_100_121 VPWR VGND VPWR VGND sky130_ef_sc_hd__decap_12
X_4279_ _4283_/A _4278_/Y _4276_/Y _2250_/A VGND VGND VPWR VPWR _4280_/B sky130_fd_sc_hd__a211o_1
XFILLER_100_165 VPWR VGND VPWR VGND sky130_ef_sc_hd__decap_12
XFILLER_86_399 VPWR VGND VPWR VGND sky130_ef_sc_hd__decap_12
XFILLER_39_293 VGND VGND VPWR VPWR sky130_fd_sc_hd__decap_4
XFILLER_15_617 VGND VGND VPWR VPWR sky130_fd_sc_hd__fill_2
XFILLER_10_333 VGND VGND VPWR VPWR sky130_fd_sc_hd__fill_2
XFILLER_52_89 VGND VGND VPWR VPWR sky130_fd_sc_hd__decap_4
XFILLER_6_326 VGND VGND VPWR VPWR sky130_fd_sc_hd__fill_1
XFILLER_10_399 VGND VGND VPWR VPWR sky130_fd_sc_hd__decap_6
XFILLER_6_348 VGND VGND VPWR VPWR sky130_fd_sc_hd__decap_4
XTAP_TAPCELL_ROW_75_1057 VGND VPWR sky130_fd_sc_hd__tapvpwrvgnd_1
XFILLER_2_510 VPWR VGND VPWR VGND sky130_ef_sc_hd__decap_12
XFILLER_97_609 VGND VGND VPWR VPWR sky130_fd_sc_hd__decap_6
XFILLER_2_587 VGND VGND VPWR VPWR sky130_fd_sc_hd__fill_1
XFILLER_77_377 VPWR VGND VPWR VGND sky130_ef_sc_hd__decap_12
XFILLER_65_517 VPWR VGND VPWR VGND sky130_ef_sc_hd__decap_12
XFILLER_18_400 VGND VGND VPWR VPWR sky130_fd_sc_hd__decap_4
XFILLER_37_208 VPWR VGND VPWR VGND sky130_ef_sc_hd__decap_12
XFILLER_18_444 VGND VGND VPWR VPWR sky130_fd_sc_hd__decap_6
XTAP_TAPCELL_ROW_48_759 VGND VPWR sky130_fd_sc_hd__tapvpwrvgnd_1
XFILLER_73_561 VPWR VGND VPWR VGND sky130_ef_sc_hd__decap_12
XTAP_TAPCELL_ROW_86_1175 VGND VPWR sky130_fd_sc_hd__tapvpwrvgnd_1
XFILLER_18_488 VGND VGND VPWR VPWR sky130_fd_sc_hd__fill_1
XFILLER_33_425 VGND VGND VPWR VPWR sky130_fd_sc_hd__fill_1
XFILLER_60_277 VPWR VGND VPWR VGND sky130_ef_sc_hd__decap_12
XTAP_TAPCELL_ROW_11_350 VGND VPWR sky130_fd_sc_hd__tapvpwrvgnd_1
X_3650_ _3650_/A _3650_/B VGND VGND VPWR VPWR _3733_/B sky130_fd_sc_hd__xnor2_1
X_2601_ _2601_/A _2601_/B VGND VGND VPWR VPWR _2603_/B sky130_fd_sc_hd__xnor2_1
X_3581_ _3581_/A _3581_/B _3581_/C VGND VGND VPWR VPWR _3583_/A sky130_fd_sc_hd__or3_1
X_2532_ _2200_/Y _2528_/Y _2534_/A2 VGND VGND VPWR VPWR _2532_/X sky130_fd_sc_hd__o21a_1
XFILLER_54_3 VPWR VGND VPWR VGND sky130_ef_sc_hd__decap_12
XFILLER_102_419 VGND VGND VPWR VPWR sky130_fd_sc_hd__fill_1
X_2463_ _2467_/C _2462_/Y _4450_/Q _2483_/B2 VGND VGND VPWR VPWR _4450_/D sky130_fd_sc_hd__a2bb2o_1
X_4202_ _4213_/A1 _4200_/Y _4204_/B _4206_/B1 hold79/X VGND VGND VPWR VPWR _4698_/D
+ sky130_fd_sc_hd__a32o_1
X_2394_ hold188/X _2408_/A2 _2408_/B1 _4495_/Q VGND VGND VPWR VPWR _2394_/X sky130_fd_sc_hd__a22o_1
X_4133_ hold168/X _4133_/A1 _4139_/S VGND VGND VPWR VPWR _4662_/D sky130_fd_sc_hd__mux2_1
XFILLER_68_377 VGND VGND VPWR VPWR sky130_fd_sc_hd__decap_4
X_4064_ _4136_/A1 hold169/X _4067_/S VGND VGND VPWR VPWR _4601_/D sky130_fd_sc_hd__mux2_1
X_3015_ _2915_/A _2947_/A _2973_/A _3014_/B VGND VGND VPWR VPWR _3015_/X sky130_fd_sc_hd__a211o_1
XFILLER_91_391 VGND VGND VPWR VPWR sky130_fd_sc_hd__fill_1
X_3917_ _3917_/A _3917_/B VGND VGND VPWR VPWR _3920_/A sky130_fd_sc_hd__xnor2_1
XFILLER_22_15 VPWR VGND VPWR VGND sky130_ef_sc_hd__decap_12
X_3848_ _4760_/Q _3849_/B _4761_/Q VGND VGND VPWR VPWR _3872_/B sky130_fd_sc_hd__a21o_1
X_3779_ _3779_/A _3779_/B VGND VGND VPWR VPWR _3788_/A sky130_fd_sc_hd__xor2_1
XFILLER_79_609 VGND VGND VPWR VPWR sky130_fd_sc_hd__decap_6
XFILLER_105_279 VGND VGND VPWR VPWR sky130_fd_sc_hd__fill_1
Xfanout121 fanout128/X VGND VGND VPWR VPWR fanout121/X sky130_fd_sc_hd__buf_2
Xfanout110 _4283_/A VGND VGND VPWR VPWR _4318_/A sky130_fd_sc_hd__buf_2
XFILLER_101_441 VGND VGND VPWR VPWR sky130_fd_sc_hd__decap_6
XFILLER_86_141 VGND VGND VPWR VPWR sky130_fd_sc_hd__decap_3
Xfanout132 fanout173/X VGND VGND VPWR VPWR fanout132/X sky130_fd_sc_hd__clkbuf_2
Xfanout154 fanout155/X VGND VGND VPWR VPWR fanout154/X sky130_fd_sc_hd__clkbuf_4
Xfanout165 fanout166/X VGND VGND VPWR VPWR fanout165/X sky130_fd_sc_hd__clkbuf_2
Xfanout143 fanout145/X VGND VGND VPWR VPWR fanout143/X sky130_fd_sc_hd__clkbuf_4
XFILLER_101_485 VPWR VGND VPWR VGND sky130_ef_sc_hd__decap_12
XFILLER_47_539 VGND VGND VPWR VPWR sky130_fd_sc_hd__fill_1
XFILLER_103_51 VGND VGND VPWR VPWR sky130_fd_sc_hd__decap_4
XFILLER_55_561 VPWR VGND VPWR VGND sky130_ef_sc_hd__decap_12
XFILLER_42_211 VPWR VGND VPWR VGND sky130_ef_sc_hd__decap_12
XTAP_TAPCELL_ROW_45_729 VGND VPWR sky130_fd_sc_hd__tapvpwrvgnd_1
XFILLER_82_391 VPWR VGND VPWR VGND sky130_ef_sc_hd__decap_12
XFILLER_70_531 VGND VGND VPWR VPWR sky130_fd_sc_hd__fill_1
XFILLER_63_55 VGND VGND VPWR VPWR sky130_fd_sc_hd__fill_1
XFILLER_42_288 VGND VGND VPWR VPWR sky130_fd_sc_hd__decap_3
XFILLER_42_299 VGND VGND VPWR VPWR sky130_fd_sc_hd__fill_2
XFILLER_7_613 VGND VGND VPWR VPWR sky130_fd_sc_hd__decap_3
XFILLER_7_602 VGND VGND VPWR VPWR sky130_fd_sc_hd__decap_3
XFILLER_97_417 VPWR VGND VPWR VGND sky130_ef_sc_hd__decap_12
XFILLER_88_41 VPWR VGND VPWR VGND sky130_ef_sc_hd__decap_12
XFILLER_69_108 VGND VGND VPWR VPWR sky130_fd_sc_hd__decap_4
XFILLER_2_395 VPWR VGND VPWR VGND sky130_ef_sc_hd__decap_12
XTAP_TAPCELL_ROW_88_1204 VGND VPWR sky130_fd_sc_hd__tapvpwrvgnd_1
XFILLER_92_166 VGND VGND VPWR VPWR sky130_fd_sc_hd__decap_4
XFILLER_73_391 VGND VGND VPWR VPWR sky130_fd_sc_hd__fill_1
XFILLER_61_553 VGND VGND VPWR VPWR sky130_fd_sc_hd__decap_6
XFILLER_61_597 VPWR VGND VPWR VGND sky130_ef_sc_hd__decap_12
X_4751_ clkload8/A _4751_/D fanout128/X VGND VGND VPWR VPWR _4751_/Q sky130_fd_sc_hd__dfrtp_1
XTAP_TAPCELL_ROW_99_1322 VGND VPWR sky130_fd_sc_hd__tapvpwrvgnd_1
X_4682_ _4684_/CLK _4682_/D fanout142/X VGND VGND VPWR VPWR hold65/A sky130_fd_sc_hd__dfrtp_1
X_3702_ _4755_/Q _3723_/C VGND VGND VPWR VPWR _3703_/B sky130_fd_sc_hd__nor2_1
X_3633_ _3633_/A _3858_/A VGND VGND VPWR VPWR _3634_/B sky130_fd_sc_hd__xnor2_2
X_3564_ _3565_/B _3565_/C _3565_/A VGND VGND VPWR VPWR _3606_/B sky130_fd_sc_hd__a21o_1
X_3495_ _3495_/A _3634_/A VGND VGND VPWR VPWR _3498_/B sky130_fd_sc_hd__xor2_2
X_2515_ _4466_/Q _2518_/C VGND VGND VPWR VPWR _2515_/X sky130_fd_sc_hd__or2_1
X_2446_ _2486_/A1 _2449_/B _2445_/X _2486_/B1 hold240/X VGND VGND VPWR VPWR _4445_/D
+ sky130_fd_sc_hd__a32o_1
XFILLER_84_601 VPWR VGND VPWR VGND sky130_ef_sc_hd__decap_12
X_4116_ hold101/X _4020_/X _4121_/S VGND VGND VPWR VPWR _4647_/D sky130_fd_sc_hd__mux2_1
XPHY_EDGE_ROW_3_Left_111 VGND VGND VPWR VPWR sky130_fd_sc_hd__decap_3
X_2377_ hold31/X _2379_/A2 _2379_/B1 _4542_/Q VGND VGND VPWR VPWR _4392_/D sky130_fd_sc_hd__a22o_1
XFILLER_83_133 VGND VGND VPWR VPWR sky130_fd_sc_hd__fill_2
X_4047_ _4137_/A1 hold157/X _4049_/S VGND VGND VPWR VPWR _4586_/D sky130_fd_sc_hd__mux2_1
XFILLER_17_15 VPWR VGND VPWR VGND sky130_ef_sc_hd__decap_12
XFILLER_37_561 VGND VGND VPWR VPWR sky130_fd_sc_hd__decap_8
XFILLER_64_391 VPWR VGND VPWR VGND sky130_ef_sc_hd__decap_12
XFILLER_33_69 VGND VGND VPWR VPWR sky130_fd_sc_hd__decap_8
XPHY_EDGE_ROW_49_Left_157 VGND VGND VPWR VPWR sky130_fd_sc_hd__decap_3
XTAP_TAPCELL_ROW_22_478 VGND VPWR sky130_fd_sc_hd__tapvpwrvgnd_1
XTAP_TAPCELL_ROW_50_787 VGND VPWR sky130_fd_sc_hd__tapvpwrvgnd_1
XFILLER_106_533 VPWR VGND VPWR VGND sky130_ef_sc_hd__decap_12
XTAP_TAPCELL_ROW_72_1027 VGND VPWR sky130_fd_sc_hd__tapvpwrvgnd_1
XFILLER_59_130 VGND VGND VPWR VPWR sky130_fd_sc_hd__decap_3
XFILLER_87_461 VPWR VGND VPWR VGND sky130_ef_sc_hd__decap_12
XPHY_EDGE_ROW_58_Left_166 VGND VGND VPWR VPWR sky130_fd_sc_hd__decap_3
XFILLER_58_77 VGND VGND VPWR VPWR sky130_fd_sc_hd__decap_6
XFILLER_59_141 VGND VGND VPWR VPWR sky130_fd_sc_hd__decap_6
XFILLER_101_293 VPWR VGND VPWR VGND sky130_ef_sc_hd__decap_12
XTAP_TAPCELL_ROW_58_865 VGND VPWR sky130_fd_sc_hd__tapvpwrvgnd_1
XFILLER_74_65 VPWR VGND VPWR VGND sky130_ef_sc_hd__decap_12
XFILLER_62_328 VGND VGND VPWR VPWR sky130_fd_sc_hd__fill_2
XTAP_TAPCELL_ROW_83_1145 VGND VPWR sky130_fd_sc_hd__tapvpwrvgnd_1
XFILLER_90_53 VPWR VGND VPWR VGND sky130_ef_sc_hd__decap_12
XPHY_EDGE_ROW_67_Left_175 VGND VGND VPWR VPWR sky130_fd_sc_hd__decap_3
XFILLER_99_51 VGND VGND VPWR VPWR sky130_fd_sc_hd__decap_4
XTAP_TAPCELL_ROW_94_1263 VGND VPWR sky130_fd_sc_hd__tapvpwrvgnd_1
XFILLER_97_225 VPWR VGND VPWR VGND sky130_ef_sc_hd__decap_12
X_2300_ _4694_/Q _2461_/A _4693_/Q _2459_/A VGND VGND VPWR VPWR _2300_/X sky130_fd_sc_hd__a22o_1
X_3280_ _3287_/A VGND VGND VPWR VPWR _3280_/Y sky130_fd_sc_hd__inv_2
XPHY_EDGE_ROW_76_Left_184 VGND VGND VPWR VPWR sky130_fd_sc_hd__decap_3
X_2231_ _4569_/Q VGND VGND VPWR VPWR _3521_/A sky130_fd_sc_hd__inv_2
XFILLER_85_409 VGND VGND VPWR VPWR sky130_fd_sc_hd__fill_1
XFILLER_66_601 VPWR VGND VPWR VGND sky130_ef_sc_hd__decap_12
XFILLER_17_3 VPWR VGND VPWR VGND sky130_ef_sc_hd__decap_12
XFILLER_81_615 VGND VGND VPWR VPWR sky130_fd_sc_hd__fill_1
XFILLER_93_497 VGND VGND VPWR VPWR sky130_fd_sc_hd__decap_6
XFILLER_65_166 VGND VGND VPWR VPWR sky130_fd_sc_hd__fill_2
XFILLER_19_594 VGND VGND VPWR VPWR sky130_fd_sc_hd__fill_2
XPHY_EDGE_ROW_85_Left_193 VGND VGND VPWR VPWR sky130_fd_sc_hd__decap_3
XFILLER_61_372 VGND VGND VPWR VPWR sky130_fd_sc_hd__fill_1
XTAP_TAPCELL_ROW_103_1370 VGND VPWR sky130_fd_sc_hd__tapvpwrvgnd_1
XFILLER_21_225 VGND VGND VPWR VPWR sky130_fd_sc_hd__fill_1
X_4734_ _4734_/CLK _4734_/D fanout147/X VGND VGND VPWR VPWR _4734_/Q sky130_fd_sc_hd__dfrtp_4
X_2995_ _2973_/A _3013_/A _2973_/B _2971_/A VGND VGND VPWR VPWR _2996_/B sky130_fd_sc_hd__o31a_1
X_4665_ clkload8/A _4665_/D fanout126/X VGND VGND VPWR VPWR _4665_/Q sky130_fd_sc_hd__dfrtp_1
X_4596_ _4661_/CLK _4596_/D fanout121/X VGND VGND VPWR VPWR _4596_/Q sky130_fd_sc_hd__dfrtp_1
X_3616_ _3583_/B _3610_/A _3610_/B VGND VGND VPWR VPWR _3644_/B sky130_fd_sc_hd__a21boi_2
X_3547_ _3575_/A _3575_/B _3520_/X VGND VGND VPWR VPWR _3548_/B sky130_fd_sc_hd__o21ba_1
XFILLER_103_503 VGND VGND VPWR VPWR sky130_fd_sc_hd__fill_1
X_3478_ _3433_/Y _3461_/B _3460_/B VGND VGND VPWR VPWR _3479_/B sky130_fd_sc_hd__o21a_1
X_2429_ _2250_/A _2250_/B _4368_/Q VGND VGND VPWR VPWR _2429_/X sky130_fd_sc_hd__a21o_1
XFILLER_56_100 VPWR VGND VPWR VGND sky130_ef_sc_hd__decap_12
XFILLER_56_133 VGND VGND VPWR VPWR sky130_fd_sc_hd__decap_6
XFILLER_84_475 VGND VGND VPWR VPWR sky130_fd_sc_hd__fill_1
XTAP_TAPCELL_ROW_27_526 VGND VPWR sky130_fd_sc_hd__tapvpwrvgnd_1
XFILLER_44_306 VGND VGND VPWR VPWR sky130_fd_sc_hd__fill_2
XTAP_TAPCELL_ROW_55_835 VGND VPWR sky130_fd_sc_hd__tapvpwrvgnd_1
XFILLER_71_158 VGND VGND VPWR VPWR sky130_fd_sc_hd__decap_8
XFILLER_71_125 VGND VGND VPWR VPWR sky130_fd_sc_hd__decap_3
XFILLER_37_391 VGND VGND VPWR VPWR sky130_fd_sc_hd__fill_1
XFILLER_71_169 VGND VGND VPWR VPWR sky130_fd_sc_hd__fill_1
XFILLER_25_575 VPWR VGND VPWR VGND sky130_ef_sc_hd__decap_12
XFILLER_12_236 VPWR VGND VPWR VGND sky130_ef_sc_hd__decap_12
XFILLER_12_214 VGND VGND VPWR VPWR sky130_fd_sc_hd__decap_6
XFILLER_100_41 VPWR VGND VPWR VGND sky130_ef_sc_hd__decap_12
XFILLER_100_85 VPWR VGND VPWR VGND sky130_ef_sc_hd__decap_12
XFILLER_106_363 VGND VGND VPWR VPWR sky130_fd_sc_hd__fill_1
XFILLER_69_87 VGND VGND VPWR VPWR sky130_fd_sc_hd__fill_1
XFILLER_94_217 VGND VGND VPWR VPWR sky130_fd_sc_hd__fill_1
XFILLER_79_269 VGND VGND VPWR VPWR sky130_fd_sc_hd__decap_8
XFILLER_94_239 VPWR VGND VPWR VGND sky130_ef_sc_hd__decap_12
XFILLER_63_615 VGND VGND VPWR VPWR sky130_fd_sc_hd__fill_1
XFILLER_47_166 VGND VGND VPWR VPWR sky130_fd_sc_hd__fill_2
XFILLER_47_188 VGND VGND VPWR VPWR sky130_fd_sc_hd__decap_4
XFILLER_90_445 VPWR VGND VPWR VGND sky130_ef_sc_hd__decap_12
XFILLER_90_489 VPWR VGND VPWR VGND sky130_ef_sc_hd__decap_12
XFILLER_50_309 VPWR VGND VPWR VGND sky130_ef_sc_hd__decap_12
XFILLER_16_586 VGND VGND VPWR VPWR sky130_fd_sc_hd__fill_2
X_2780_ _2734_/A _2757_/A _2755_/B _4499_/Q _2758_/A VGND VGND VPWR VPWR _2782_/C
+ sky130_fd_sc_hd__a221o_1
Xhold207 _4401_/Q VGND VGND VPWR VPWR hold207/X sky130_fd_sc_hd__dlygate4sd3_1
X_4450_ _4721_/CLK _4450_/D fanout158/X VGND VGND VPWR VPWR _4450_/Q sky130_fd_sc_hd__dfrtp_1
Xhold218 _4487_/Q VGND VGND VPWR VPWR hold218/X sky130_fd_sc_hd__dlygate4sd3_1
X_3401_ _3401_/A _3401_/B VGND VGND VPWR VPWR _3402_/B sky130_fd_sc_hd__xnor2_1
Xhold229 _4699_/Q VGND VGND VPWR VPWR hold229/X sky130_fd_sc_hd__dlygate4sd3_1
X_4381_ _4531_/CLK _4381_/D fanout150/X VGND VGND VPWR VPWR hold30/A sky130_fd_sc_hd__dfrtp_1
XFILLER_98_501 VPWR VGND VPWR VGND sky130_ef_sc_hd__decap_12
X_3332_ _3332_/A _3332_/B VGND VGND VPWR VPWR _3334_/B sky130_fd_sc_hd__xnor2_1
XFILLER_98_545 VPWR VGND VPWR VGND sky130_ef_sc_hd__decap_12
XFILLER_98_589 VPWR VGND VPWR VGND sky130_ef_sc_hd__decap_12
X_3263_ _4743_/Q _4744_/Q _3409_/B VGND VGND VPWR VPWR _3456_/B sky130_fd_sc_hd__or3_1
X_3194_ _4585_/Q hold44/A hold95/A _4681_/Q _3246_/S0 _3246_/S1 VGND VGND VPWR VPWR
+ _3195_/B sky130_fd_sc_hd__mux4_1
X_2214_ _4459_/Q VGND VGND VPWR VPWR _2214_/Y sky130_fd_sc_hd__inv_2
XPHY_EDGE_ROW_93_Left_201 VGND VGND VPWR VPWR sky130_fd_sc_hd__decap_3
Xclkbuf_3_5__f_clk clkbuf_0_clk/X VGND VGND VPWR VPWR _4459_/CLK sky130_fd_sc_hd__clkbuf_16
XTAP_TAPCELL_ROW_52_805 VGND VPWR sky130_fd_sc_hd__tapvpwrvgnd_1
XFILLER_14_27 VGND VGND VPWR VPWR sky130_fd_sc_hd__fill_1
XFILLER_22_589 VGND VGND VPWR VPWR sky130_fd_sc_hd__decap_6
XTAP_TAPCELL_ROW_32_584 VGND VPWR sky130_fd_sc_hd__tapvpwrvgnd_1
X_2978_ _2928_/A _2954_/A _2953_/A VGND VGND VPWR VPWR _2981_/B sky130_fd_sc_hd__a21oi_1
XTAP_TAPCELL_ROW_60_893 VGND VPWR sky130_fd_sc_hd__tapvpwrvgnd_1
X_4717_ _4721_/CLK _4717_/D fanout157/X VGND VGND VPWR VPWR _4717_/Q sky130_fd_sc_hd__dfrtp_2
X_4648_ _4679_/CLK _4648_/D fanout138/X VGND VGND VPWR VPWR _4648_/Q sky130_fd_sc_hd__dfrtp_1
XFILLER_30_15 VPWR VGND VPWR VGND sky130_ef_sc_hd__decap_12
X_4579_ _4758_/CLK _4579_/D fanout140/X VGND VGND VPWR VPWR _4579_/Q sky130_fd_sc_hd__dfrtp_1
XFILLER_39_57 VGND VGND VPWR VPWR sky130_fd_sc_hd__decap_8
XFILLER_76_217 VGND VGND VPWR VPWR sky130_fd_sc_hd__fill_2
XFILLER_72_401 VGND VGND VPWR VPWR sky130_fd_sc_hd__fill_2
XTAP_TAPCELL_ROW_68_982 VGND VPWR sky130_fd_sc_hd__tapvpwrvgnd_1
XTAP_TAPCELL_ROW_4_276 VGND VPWR sky130_fd_sc_hd__tapvpwrvgnd_1
XFILLER_72_489 VPWR VGND VPWR VGND sky130_ef_sc_hd__decap_12
XFILLER_32_309 VGND VGND VPWR VPWR sky130_fd_sc_hd__decap_6
XFILLER_44_169 VGND VGND VPWR VPWR sky130_fd_sc_hd__fill_1
XTAP_TAPCELL_ROW_80_1115 VGND VPWR sky130_fd_sc_hd__tapvpwrvgnd_1
XFILLER_71_55 VGND VGND VPWR VPWR sky130_fd_sc_hd__fill_1
XFILLER_13_567 VPWR VGND VPWR VGND sky130_ef_sc_hd__decap_12
XFILLER_52_191 VGND VGND VPWR VPWR sky130_fd_sc_hd__decap_4
XFILLER_13_589 VGND VGND VPWR VPWR sky130_fd_sc_hd__decap_6
XTAP_TAPCELL_ROW_78_1088 VGND VPWR sky130_fd_sc_hd__tapvpwrvgnd_1
XTAP_TAPCELL_ROW_91_1233 VGND VPWR sky130_fd_sc_hd__tapvpwrvgnd_1
XFILLER_96_41 VPWR VGND VPWR VGND sky130_ef_sc_hd__decap_12
XFILLER_96_85 VPWR VGND VPWR VGND sky130_ef_sc_hd__decap_12
XFILLER_95_559 VGND VGND VPWR VPWR sky130_fd_sc_hd__fill_1
Xhold90 hold90/A VGND VGND VPWR VPWR hold90/X sky130_fd_sc_hd__dlygate4sd3_1
XFILLER_90_231 VPWR VGND VPWR VGND sky130_ef_sc_hd__decap_12
XFILLER_63_434 VGND VGND VPWR VPWR sky130_fd_sc_hd__decap_6
XFILLER_90_253 VPWR VGND VPWR VGND sky130_ef_sc_hd__decap_12
X_3950_ _3950_/A _3950_/B VGND VGND VPWR VPWR _3951_/B sky130_fd_sc_hd__xnor2_1
XFILLER_51_629 VGND VGND VPWR VPWR sky130_fd_sc_hd__decap_8
X_2901_ _2325_/C _3696_/A _4339_/A2 _4505_/Q VGND VGND VPWR VPWR _4505_/D sky130_fd_sc_hd__a2bb2o_1
X_3881_ _3967_/A _3882_/B VGND VGND VPWR VPWR _3881_/Y sky130_fd_sc_hd__nor2_1
XFILLER_84_3 VPWR VGND VPWR VGND sky130_ef_sc_hd__decap_12
X_2832_ _2831_/B _2781_/Y _2831_/C _2830_/Y VGND VGND VPWR VPWR _2834_/C sky130_fd_sc_hd__o31a_1
X_2763_ _4746_/Q _2810_/B VGND VGND VPWR VPWR _2807_/A sky130_fd_sc_hd__xnor2_1
X_4502_ _4504_/CLK _4502_/D fanout131/X VGND VGND VPWR VPWR _4502_/Q sky130_fd_sc_hd__dfrtp_1
XFILLER_105_609 VGND VGND VPWR VPWR sky130_fd_sc_hd__decap_6
X_2694_ _4743_/Q _2694_/B VGND VGND VPWR VPWR _2710_/B sky130_fd_sc_hd__xnor2_1
XFILLER_6_83 VGND VGND VPWR VPWR sky130_fd_sc_hd__fill_1
X_4433_ _4539_/CLK _4433_/D fanout169/X VGND VGND VPWR VPWR _4433_/Q sky130_fd_sc_hd__dfrtp_1
X_4364_ _4706_/CLK _4364_/D fanout160/X VGND VGND VPWR VPWR _4364_/Q sky130_fd_sc_hd__dfstp_1
X_4295_ uo_out[3] _4294_/Y _4323_/S VGND VGND VPWR VPWR _4722_/D sky130_fd_sc_hd__mux2_1
X_3315_ _3315_/A _3315_/B VGND VGND VPWR VPWR _3315_/Y sky130_fd_sc_hd__nand2_1
X_3246_ _4588_/Q hold51/A _4652_/Q hold97/A _3246_/S0 _3246_/S1 VGND VGND VPWR VPWR
+ _3250_/A sky130_fd_sc_hd__mux4_1
XFILLER_58_217 VGND VGND VPWR VPWR sky130_fd_sc_hd__decap_8
XFILLER_94_581 VGND VGND VPWR VPWR sky130_fd_sc_hd__decap_6
X_3177_ _3197_/A _3177_/B VGND VGND VPWR VPWR _3179_/C sky130_fd_sc_hd__nand2_1
XFILLER_81_231 VGND VGND VPWR VPWR sky130_fd_sc_hd__fill_1
XTAP_TAPCELL_ROW_1_246 VGND VPWR sky130_fd_sc_hd__tapvpwrvgnd_1
XTAP_TAPCELL_ROW_65_952 VGND VPWR sky130_fd_sc_hd__tapvpwrvgnd_1
XFILLER_14_309 VPWR VGND VPWR VGND sky130_ef_sc_hd__decap_12
XFILLER_25_15 VPWR VGND VPWR VGND sky130_ef_sc_hd__decap_12
XTAP_TAPCELL_ROW_37_643 VGND VPWR sky130_fd_sc_hd__tapvpwrvgnd_1
XFILLER_42_629 VGND VGND VPWR VPWR sky130_fd_sc_hd__decap_8
XFILLER_54_489 VGND VGND VPWR VPWR sky130_fd_sc_hd__decap_8
XFILLER_41_139 VGND VGND VPWR VPWR sky130_fd_sc_hd__decap_3
XFILLER_22_353 VGND VGND VPWR VPWR sky130_fd_sc_hd__decap_4
XFILLER_41_69 VGND VGND VPWR VPWR sky130_fd_sc_hd__decap_3
XFILLER_89_320 VGND VGND VPWR VPWR sky130_fd_sc_hd__decap_3
XTAP_TAPCELL_ROW_9_335 VGND VPWR sky130_fd_sc_hd__tapvpwrvgnd_1
XFILLER_77_559 VGND VGND VPWR VPWR sky130_fd_sc_hd__fill_1
XFILLER_66_77 VGND VGND VPWR VPWR sky130_fd_sc_hd__decap_6
XFILLER_18_604 VGND VGND VPWR VPWR sky130_fd_sc_hd__decap_8
XFILLER_72_220 VPWR VGND VPWR VGND sky130_ef_sc_hd__decap_12
XFILLER_45_445 VGND VGND VPWR VPWR sky130_fd_sc_hd__decap_3
XFILLER_72_253 VGND VGND VPWR VPWR sky130_fd_sc_hd__decap_8
XFILLER_17_169 VGND VGND VPWR VPWR sky130_fd_sc_hd__fill_1
XFILLER_82_65 VPWR VGND VPWR VGND sky130_ef_sc_hd__decap_12
XFILLER_33_629 VGND VGND VPWR VPWR sky130_fd_sc_hd__decap_8
XFILLER_13_342 VGND VGND VPWR VPWR sky130_fd_sc_hd__decap_8
XFILLER_13_375 VPWR VGND VPWR VGND sky130_ef_sc_hd__decap_12
XFILLER_13_364 VGND VGND VPWR VPWR sky130_fd_sc_hd__fill_1
XFILLER_9_324 VGND VGND VPWR VPWR sky130_fd_sc_hd__decap_3
XFILLER_15_81 VGND VGND VPWR VPWR sky130_fd_sc_hd__decap_8
XFILLER_9_379 VPWR VGND VPWR VGND sky130_ef_sc_hd__decap_12
XFILLER_5_530 VGND VGND VPWR VPWR sky130_fd_sc_hd__fill_1
XFILLER_5_596 VGND VGND VPWR VPWR sky130_fd_sc_hd__decap_3
X_3100_ _3100_/A _3100_/B _3100_/C VGND VGND VPWR VPWR _3676_/B sky130_fd_sc_hd__nand3_2
X_4080_ _4155_/A1 _4013_/Y _4135_/A1 _2352_/A hold45/X VGND VGND VPWR VPWR _4616_/D
+ sky130_fd_sc_hd__a32o_1
XFILLER_83_529 VPWR VGND VPWR VGND sky130_ef_sc_hd__decap_12
XFILLER_36_401 VGND VGND VPWR VPWR sky130_fd_sc_hd__decap_8
X_3031_ _2981_/B _3028_/C _3030_/Y _2998_/Y VGND VGND VPWR VPWR _3106_/A sky130_fd_sc_hd__o22a_1
XFILLER_76_581 VGND VGND VPWR VPWR sky130_fd_sc_hd__decap_6
XFILLER_36_445 VGND VGND VPWR VPWR sky130_fd_sc_hd__decap_4
XFILLER_91_573 VPWR VGND VPWR VGND sky130_ef_sc_hd__decap_12
XFILLER_63_264 VPWR VGND VPWR VGND sky130_ef_sc_hd__decap_12
XFILLER_63_297 VGND VGND VPWR VPWR sky130_fd_sc_hd__decap_8
XTAP_TAPCELL_ROW_62_911 VGND VPWR sky130_fd_sc_hd__tapvpwrvgnd_1
XTAP_TAPCELL_ROW_34_602 VGND VPWR sky130_fd_sc_hd__tapvpwrvgnd_1
X_3933_ _3931_/A _3931_/B _3932_/Y _3930_/Y _3907_/Y VGND VGND VPWR VPWR _3933_/Y
+ sky130_fd_sc_hd__o32ai_1
X_3864_ _3864_/A _3864_/B VGND VGND VPWR VPWR _3866_/B sky130_fd_sc_hd__xnor2_1
XTAP_TAPCELL_ROW_14_381 VGND VPWR sky130_fd_sc_hd__tapvpwrvgnd_1
X_2815_ _4530_/Q _4539_/Q VGND VGND VPWR VPWR _2817_/B sky130_fd_sc_hd__xor2_1
XTAP_TAPCELL_ROW_42_690 VGND VPWR sky130_fd_sc_hd__tapvpwrvgnd_1
X_3795_ _3783_/B _3787_/B _3783_/A VGND VGND VPWR VPWR _3809_/A sky130_fd_sc_hd__a21bo_1
XFILLER_11_39 VPWR VGND VPWR VGND sky130_ef_sc_hd__decap_12
X_2746_ hold92/A _4598_/Q _2746_/S VGND VGND VPWR VPWR _2747_/B sky130_fd_sc_hd__mux2_1
XFILLER_105_417 VPWR VGND VPWR VGND sky130_ef_sc_hd__decap_12
X_2677_ _4524_/Q _4533_/Q VGND VGND VPWR VPWR _2679_/B sky130_fd_sc_hd__xor2_1
X_4416_ _4504_/CLK hold12/X fanout154/X VGND VGND VPWR VPWR hold11/A sky130_fd_sc_hd__dfrtp_1
XFILLER_86_301 VGND VGND VPWR VPWR sky130_fd_sc_hd__decap_6
X_4347_ hold265/X _4354_/A2 _3805_/A _4354_/B2 VGND VGND VPWR VPWR _4759_/D sky130_fd_sc_hd__a22o_1
XFILLER_100_133 VGND VGND VPWR VPWR sky130_fd_sc_hd__decap_6
XFILLER_59_559 VGND VGND VPWR VPWR sky130_fd_sc_hd__fill_1
XPHY_EDGE_ROW_21_Left_129 VGND VGND VPWR VPWR sky130_fd_sc_hd__decap_3
X_4278_ _4278_/A VGND VGND VPWR VPWR _4278_/Y sky130_fd_sc_hd__inv_2
XFILLER_100_177 VPWR VGND VPWR VGND sky130_ef_sc_hd__decap_12
X_3229_ _4587_/Q hold54/A _4651_/Q hold74/A _3246_/S0 _3246_/S1 VGND VGND VPWR VPWR
+ _3231_/B sky130_fd_sc_hd__mux4_1
XFILLER_46_209 VGND VGND VPWR VPWR sky130_fd_sc_hd__fill_2
XFILLER_27_445 VGND VGND VPWR VPWR sky130_fd_sc_hd__decap_3
XFILLER_27_456 VGND VGND VPWR VPWR sky130_fd_sc_hd__fill_2
XFILLER_42_459 VGND VGND VPWR VPWR sky130_fd_sc_hd__decap_4
XFILLER_22_150 VGND VGND VPWR VPWR sky130_fd_sc_hd__decap_3
XPHY_EDGE_ROW_30_Left_138 VGND VGND VPWR VPWR sky130_fd_sc_hd__decap_3
XFILLER_50_481 VGND VGND VPWR VPWR sky130_fd_sc_hd__fill_1
XTAP_TAPCELL_ROW_75_1058 VGND VPWR sky130_fd_sc_hd__tapvpwrvgnd_1
XFILLER_2_522 VGND VGND VPWR VPWR sky130_fd_sc_hd__decap_8
XFILLER_2_533 VPWR VGND VPWR VGND sky130_ef_sc_hd__decap_12
XFILLER_96_109 VPWR VGND VPWR VGND sky130_ef_sc_hd__decap_12
XFILLER_77_389 VGND VGND VPWR VPWR sky130_fd_sc_hd__decap_3
XFILLER_65_529 VPWR VGND VPWR VGND sky130_ef_sc_hd__decap_12
XFILLER_58_581 VGND VGND VPWR VPWR sky130_fd_sc_hd__decap_6
XTAP_TAPCELL_ROW_86_1176 VGND VPWR sky130_fd_sc_hd__tapvpwrvgnd_1
XFILLER_73_573 VPWR VGND VPWR VGND sky130_ef_sc_hd__decap_12
XFILLER_45_264 VGND VGND VPWR VPWR sky130_fd_sc_hd__decap_8
XFILLER_60_289 VPWR VGND VPWR VGND sky130_ef_sc_hd__decap_12
XFILLER_9_110 VGND VGND VPWR VPWR sky130_fd_sc_hd__fill_2
X_2600_ _2600_/A _2600_/B VGND VGND VPWR VPWR _2601_/B sky130_fd_sc_hd__xnor2_2
XTAP_TAPCELL_ROW_11_351 VGND VPWR sky130_fd_sc_hd__tapvpwrvgnd_1
X_3580_ _3578_/Y _3580_/B _3606_/B VGND VGND VPWR VPWR _3581_/C sky130_fd_sc_hd__and3b_1
X_2531_ _4471_/Q _2531_/B VGND VGND VPWR VPWR _2531_/X sky130_fd_sc_hd__or2_1
XTAP_TAPCELL_ROW_97_1294 VGND VPWR sky130_fd_sc_hd__tapvpwrvgnd_1
XFILLER_5_371 VGND VGND VPWR VPWR sky130_fd_sc_hd__decap_3
X_2462_ _4450_/Q _2458_/A _2482_/B1 VGND VGND VPWR VPWR _2462_/Y sky130_fd_sc_hd__o21ai_1
X_4201_ _4201_/A _4201_/B VGND VGND VPWR VPWR _4204_/B sky130_fd_sc_hd__or2_1
XFILLER_47_3 VPWR VGND VPWR VGND sky130_ef_sc_hd__decap_12
X_2393_ _4408_/Q _2395_/A2 _2395_/B1 hold220/X VGND VGND VPWR VPWR _2393_/X sky130_fd_sc_hd__a22o_1
XFILLER_3_51 VGND VGND VPWR VPWR sky130_fd_sc_hd__decap_4
X_4132_ hold146/X _4132_/A1 _4139_/S VGND VGND VPWR VPWR _4661_/D sky130_fd_sc_hd__mux2_1
XFILLER_68_389 VPWR VGND VPWR VGND sky130_ef_sc_hd__decap_12
XFILLER_28_209 VGND VGND VPWR VPWR sky130_fd_sc_hd__fill_1
X_4063_ _4135_/A1 hold177/X _4067_/S VGND VGND VPWR VPWR _4600_/D sky130_fd_sc_hd__mux2_1
XFILLER_83_337 VPWR VGND VPWR VGND sky130_ef_sc_hd__decap_12
X_3014_ _3014_/A _3014_/B VGND VGND VPWR VPWR _3014_/X sky130_fd_sc_hd__or2_1
XTAP_TAPCELL_ROW_19_440 VGND VPWR sky130_fd_sc_hd__tapvpwrvgnd_1
XFILLER_36_253 VGND VGND VPWR VPWR sky130_fd_sc_hd__fill_2
X_3916_ _3917_/A _3917_/B VGND VGND VPWR VPWR _3943_/A sky130_fd_sc_hd__nand2b_1
XFILLER_11_109 VGND VGND VPWR VPWR sky130_fd_sc_hd__decap_3
X_3847_ _3847_/A _3847_/B VGND VGND VPWR VPWR _3869_/A sky130_fd_sc_hd__nor2_1
XFILLER_22_27 VGND VGND VPWR VPWR sky130_fd_sc_hd__fill_1
X_3778_ _3778_/A _3779_/A _3778_/C VGND VGND VPWR VPWR _3819_/A sky130_fd_sc_hd__and3_1
X_2729_ _2820_/A _2729_/B VGND VGND VPWR VPWR _2730_/B sky130_fd_sc_hd__xnor2_1
XFILLER_105_225 VPWR VGND VPWR VGND sky130_ef_sc_hd__decap_12
Xfanout122 fanout123/X VGND VGND VPWR VPWR fanout122/X sky130_fd_sc_hd__clkbuf_4
Xfanout100 _2746_/S VGND VGND VPWR VPWR _3257_/A sky130_fd_sc_hd__clkbuf_4
Xfanout111 _4438_/Q VGND VGND VPWR VPWR _4283_/A sky130_fd_sc_hd__buf_2
XFILLER_86_131 VGND VGND VPWR VPWR sky130_fd_sc_hd__fill_1
XFILLER_86_120 VGND VGND VPWR VPWR sky130_fd_sc_hd__decap_3
Xfanout144 fanout145/X VGND VGND VPWR VPWR fanout144/X sky130_fd_sc_hd__buf_4
Xfanout155 fanout173/X VGND VGND VPWR VPWR fanout155/X sky130_fd_sc_hd__buf_2
Xfanout133 fanout135/X VGND VGND VPWR VPWR fanout133/X sky130_fd_sc_hd__clkbuf_4
XFILLER_59_334 VGND VGND VPWR VPWR sky130_fd_sc_hd__fill_2
XFILLER_59_345 VGND VGND VPWR VPWR sky130_fd_sc_hd__fill_1
Xfanout166 fanout173/X VGND VGND VPWR VPWR fanout166/X sky130_fd_sc_hd__buf_2
XFILLER_101_497 VGND VGND VPWR VPWR sky130_fd_sc_hd__decap_6
XFILLER_74_326 VGND VGND VPWR VPWR sky130_fd_sc_hd__fill_1
XPHY_EDGE_ROW_29_Right_29 VGND VGND VPWR VPWR sky130_fd_sc_hd__decap_3
XFILLER_47_57 VPWR VGND VPWR VGND sky130_ef_sc_hd__decap_12
XFILLER_55_573 VPWR VGND VPWR VGND sky130_ef_sc_hd__decap_12
XFILLER_42_223 VGND VGND VPWR VPWR sky130_fd_sc_hd__fill_1
XFILLER_70_587 VGND VGND VPWR VPWR sky130_fd_sc_hd__fill_1
XFILLER_8_29 VPWR VGND VPWR VGND sky130_ef_sc_hd__decap_12
XPHY_EDGE_ROW_38_Right_38 VGND VGND VPWR VPWR sky130_fd_sc_hd__decap_3
XFILLER_88_53 VPWR VGND VPWR VGND sky130_ef_sc_hd__decap_12
XFILLER_97_429 VPWR VGND VPWR VGND sky130_ef_sc_hd__decap_12
XTAP_TAPCELL_ROW_88_1205 VGND VPWR sky130_fd_sc_hd__tapvpwrvgnd_1
XFILLER_38_507 VPWR VGND VPWR VGND sky130_ef_sc_hd__decap_12
XPHY_EDGE_ROW_47_Right_47 VGND VGND VPWR VPWR sky130_fd_sc_hd__decap_3
XFILLER_92_123 VPWR VGND VPWR VGND sky130_ef_sc_hd__decap_12
XFILLER_65_337 VGND VGND VPWR VPWR sky130_fd_sc_hd__decap_4
XFILLER_92_145 VGND VGND VPWR VPWR sky130_fd_sc_hd__fill_1
XFILLER_80_307 VGND VGND VPWR VPWR sky130_fd_sc_hd__fill_1
XFILLER_18_253 VPWR VGND VPWR VGND sky130_ef_sc_hd__decap_12
XFILLER_18_275 VPWR VGND VPWR VGND sky130_ef_sc_hd__decap_12
XTAP_TAPCELL_ROW_16_410 VGND VPWR sky130_fd_sc_hd__tapvpwrvgnd_1
XFILLER_18_297 VGND VGND VPWR VPWR sky130_fd_sc_hd__decap_4
XFILLER_33_223 VGND VGND VPWR VPWR sky130_fd_sc_hd__fill_1
X_4750_ _4750_/CLK _4750_/D fanout131/X VGND VGND VPWR VPWR _4750_/Q sky130_fd_sc_hd__dfrtp_1
XPHY_EDGE_ROW_56_Right_56 VGND VGND VPWR VPWR sky130_fd_sc_hd__decap_3
XTAP_TAPCELL_ROW_99_1323 VGND VPWR sky130_fd_sc_hd__tapvpwrvgnd_1
X_4681_ _4684_/CLK _4681_/D fanout142/X VGND VGND VPWR VPWR _4681_/Q sky130_fd_sc_hd__dfrtp_1
X_3701_ _4755_/Q _3723_/C VGND VGND VPWR VPWR _3755_/C sky130_fd_sc_hd__and2_1
X_3632_ _3565_/C _3628_/X _3631_/Y VGND VGND VPWR VPWR _3637_/B sky130_fd_sc_hd__o21a_1
X_3563_ _3648_/A _3542_/B _3562_/X VGND VGND VPWR VPWR _3565_/C sky130_fd_sc_hd__o21ai_1
XFILLER_5_190 VPWR VGND VPWR VGND sky130_ef_sc_hd__decap_12
X_3494_ _3556_/A _3483_/B _3482_/X _3486_/B VGND VGND VPWR VPWR _3508_/A sky130_fd_sc_hd__a22o_1
X_2514_ _4466_/Q _2518_/C VGND VGND VPWR VPWR _2514_/Y sky130_fd_sc_hd__nand2_1
XPHY_EDGE_ROW_65_Right_65 VGND VGND VPWR VPWR sky130_fd_sc_hd__decap_3
X_2445_ _4445_/Q _2445_/B VGND VGND VPWR VPWR _2445_/X sky130_fd_sc_hd__or2_1
XFILLER_84_613 VPWR VGND VPWR VGND sky130_ef_sc_hd__decap_12
X_4115_ hold80/X _4018_/X _4121_/S VGND VGND VPWR VPWR _4646_/D sky130_fd_sc_hd__mux2_1
X_2376_ hold32/X _2379_/A2 _2379_/B1 _4541_/Q VGND VGND VPWR VPWR _4391_/D sky130_fd_sc_hd__a22o_1
XFILLER_68_197 VGND VGND VPWR VPWR sky130_fd_sc_hd__decap_8
X_4046_ _4136_/A1 hold156/X _4049_/S VGND VGND VPWR VPWR _4585_/D sky130_fd_sc_hd__mux2_1
XFILLER_17_27 VPWR VGND VPWR VGND sky130_ef_sc_hd__decap_12
XPHY_EDGE_ROW_74_Right_74 VGND VGND VPWR VPWR sky130_fd_sc_hd__decap_3
XFILLER_33_15 VPWR VGND VPWR VGND sky130_ef_sc_hd__decap_12
XTAP_TAPCELL_ROW_50_777 VGND VPWR sky130_fd_sc_hd__tapvpwrvgnd_1
XPHY_EDGE_ROW_104_Left_212 VGND VGND VPWR VPWR sky130_fd_sc_hd__decap_3
XTAP_TAPCELL_ROW_22_479 VGND VPWR sky130_fd_sc_hd__tapvpwrvgnd_1
XFILLER_4_617 VPWR VGND VPWR VGND sky130_ef_sc_hd__decap_12
XFILLER_106_501 VPWR VGND VPWR VGND sky130_ef_sc_hd__decap_12
XFILLER_3_105 VGND VGND VPWR VPWR sky130_fd_sc_hd__decap_6
XFILLER_106_545 VPWR VGND VPWR VGND sky130_ef_sc_hd__decap_12
XPHY_EDGE_ROW_83_Right_83 VGND VGND VPWR VPWR sky130_fd_sc_hd__decap_3
XFILLER_106_589 VPWR VGND VPWR VGND sky130_ef_sc_hd__decap_12
XTAP_TAPCELL_ROW_72_1028 VGND VPWR sky130_fd_sc_hd__tapvpwrvgnd_1
XFILLER_87_473 VPWR VGND VPWR VGND sky130_ef_sc_hd__decap_12
XFILLER_101_261 VPWR VGND VPWR VGND sky130_ef_sc_hd__decap_12
XFILLER_47_337 VGND VGND VPWR VPWR sky130_fd_sc_hd__decap_8
XFILLER_47_359 VGND VGND VPWR VPWR sky130_fd_sc_hd__decap_4
XTAP_TAPCELL_ROW_58_866 VGND VPWR sky130_fd_sc_hd__tapvpwrvgnd_1
XFILLER_74_77 VGND VGND VPWR VPWR sky130_fd_sc_hd__decap_6
XPHY_EDGE_ROW_92_Right_92 VGND VGND VPWR VPWR sky130_fd_sc_hd__decap_3
XFILLER_15_223 VGND VGND VPWR VPWR sky130_fd_sc_hd__fill_1
XFILLER_43_543 VGND VGND VPWR VPWR sky130_fd_sc_hd__decap_4
XTAP_TAPCELL_ROW_83_1146 VGND VPWR sky130_fd_sc_hd__tapvpwrvgnd_1
XFILLER_15_289 VGND VGND VPWR VPWR sky130_fd_sc_hd__decap_8
XFILLER_90_65 VPWR VGND VPWR VGND sky130_ef_sc_hd__decap_12
XFILLER_90_98 VGND VGND VPWR VPWR sky130_fd_sc_hd__decap_3
XFILLER_23_81 VGND VGND VPWR VPWR sky130_fd_sc_hd__decap_8
XTAP_TAPCELL_ROW_94_1264 VGND VPWR sky130_fd_sc_hd__tapvpwrvgnd_1
XFILLER_97_237 VPWR VGND VPWR VGND sky130_ef_sc_hd__decap_12
X_2230_ _4536_/Q VGND VGND VPWR VPWR _3581_/A sky130_fd_sc_hd__inv_2
XFILLER_66_613 VPWR VGND VPWR VGND sky130_ef_sc_hd__decap_12
XFILLER_38_315 VPWR VGND VPWR VGND sky130_ef_sc_hd__decap_12
XFILLER_0_41 VGND VGND VPWR VPWR sky130_fd_sc_hd__decap_8
XFILLER_80_137 VGND VGND VPWR VPWR sky130_fd_sc_hd__decap_3
XFILLER_0_85 VPWR VGND VPWR VGND sky130_ef_sc_hd__decap_12
XFILLER_34_576 VGND VGND VPWR VPWR sky130_fd_sc_hd__decap_4
XTAP_TAPCELL_ROW_103_1360 VGND VPWR sky130_fd_sc_hd__tapvpwrvgnd_1
XPHY_EDGE_ROW_100_Right_100 VGND VGND VPWR VPWR sky130_fd_sc_hd__decap_3
XFILLER_21_215 VGND VGND VPWR VPWR sky130_fd_sc_hd__decap_8
X_2994_ _2994_/A _2994_/B VGND VGND VPWR VPWR _3013_/B sky130_fd_sc_hd__or2_1
X_4733_ _4734_/CLK _4733_/D fanout147/X VGND VGND VPWR VPWR _4733_/Q sky130_fd_sc_hd__dfrtp_4
XFILLER_107_309 VPWR VGND VPWR VGND sky130_ef_sc_hd__decap_12
X_4664_ _4667_/CLK _4664_/D fanout124/X VGND VGND VPWR VPWR _4664_/Q sky130_fd_sc_hd__dfrtp_1
X_4595_ _4661_/CLK _4595_/D fanout121/X VGND VGND VPWR VPWR _4595_/Q sky130_fd_sc_hd__dfrtp_1
X_3615_ _3538_/B _3585_/Y _3586_/Y _3614_/X VGND VGND VPWR VPWR _3644_/A sky130_fd_sc_hd__o211a_1
X_3546_ _3546_/A _3546_/B VGND VGND VPWR VPWR _3575_/C sky130_fd_sc_hd__xnor2_1
XFILLER_1_609 VGND VGND VPWR VPWR sky130_fd_sc_hd__decap_6
XFILLER_103_559 VGND VGND VPWR VPWR sky130_fd_sc_hd__fill_1
X_3477_ _3430_/A _3430_/B _3435_/Y _3461_/B VGND VGND VPWR VPWR _3479_/A sky130_fd_sc_hd__a211o_1
X_2428_ _2427_/X _2425_/X _4318_/A VGND VGND VPWR VPWR _4438_/D sky130_fd_sc_hd__mux2_1
XFILLER_84_421 VPWR VGND VPWR VGND sky130_ef_sc_hd__decap_12
X_2359_ hold81/X _2395_/A2 _2395_/B1 _4524_/Q VGND VGND VPWR VPWR _4374_/D sky130_fd_sc_hd__a22o_1
XFILLER_28_15 VPWR VGND VPWR VGND sky130_ef_sc_hd__decap_12
XFILLER_29_304 VGND VGND VPWR VPWR sky130_fd_sc_hd__fill_1
XFILLER_56_112 VGND VGND VPWR VPWR sky130_fd_sc_hd__fill_1
XFILLER_71_104 VGND VGND VPWR VPWR sky130_fd_sc_hd__decap_8
X_4029_ _4095_/B _4094_/B _4138_/A1 _4016_/Y hold77/X VGND VGND VPWR VPWR _4571_/D
+ sky130_fd_sc_hd__a32o_1
XTAP_TAPCELL_ROW_27_527 VGND VPWR sky130_fd_sc_hd__tapvpwrvgnd_1
XTAP_TAPCELL_ROW_55_836 VGND VPWR sky130_fd_sc_hd__tapvpwrvgnd_1
XFILLER_25_587 VGND VGND VPWR VPWR sky130_fd_sc_hd__fill_2
XFILLER_40_513 VGND VGND VPWR VPWR sky130_fd_sc_hd__fill_1
XFILLER_100_53 VPWR VGND VPWR VGND sky130_ef_sc_hd__decap_12
XFILLER_12_248 VGND VGND VPWR VPWR sky130_fd_sc_hd__decap_4
XFILLER_100_97 VPWR VGND VPWR VGND sky130_ef_sc_hd__decap_12
XFILLER_69_55 VGND VGND VPWR VPWR sky130_fd_sc_hd__fill_1
XFILLER_102_581 VGND VGND VPWR VPWR sky130_fd_sc_hd__decap_6
XFILLER_87_281 VGND VGND VPWR VPWR sky130_fd_sc_hd__decap_6
XFILLER_75_421 VGND VGND VPWR VPWR sky130_fd_sc_hd__decap_3
XFILLER_48_613 VPWR VGND VPWR VGND sky130_ef_sc_hd__decap_12
XFILLER_85_98 VGND VGND VPWR VPWR sky130_fd_sc_hd__decap_3
XFILLER_90_457 VPWR VGND VPWR VGND sky130_ef_sc_hd__decap_12
XFILLER_11_281 VGND VGND VPWR VPWR sky130_fd_sc_hd__decap_8
XFILLER_7_263 VGND VGND VPWR VPWR sky130_fd_sc_hd__fill_1
XFILLER_7_252 VGND VGND VPWR VPWR sky130_fd_sc_hd__decap_4
Xhold208 _4421_/Q VGND VGND VPWR VPWR hold208/X sky130_fd_sc_hd__dlygate4sd3_1
X_3400_ _3380_/A _3378_/A _3378_/B VGND VGND VPWR VPWR _3401_/B sky130_fd_sc_hd__o21bai_1
X_4380_ _4532_/CLK _4380_/D fanout153/X VGND VGND VPWR VPWR hold35/A sky130_fd_sc_hd__dfrtp_1
Xhold219 _4705_/Q VGND VGND VPWR VPWR hold219/X sky130_fd_sc_hd__dlygate4sd3_1
XFILLER_98_513 VPWR VGND VPWR VGND sky130_ef_sc_hd__decap_12
X_3331_ _3331_/A _3331_/B VGND VGND VPWR VPWR _3332_/B sky130_fd_sc_hd__xnor2_1
XFILLER_98_557 VPWR VGND VPWR VGND sky130_ef_sc_hd__decap_12
X_3262_ _4743_/Q _3409_/B VGND VGND VPWR VPWR _3431_/B sky130_fd_sc_hd__nor2_1
X_3193_ _4517_/Q _4355_/A2 _3192_/Y _3978_/A VGND VGND VPWR VPWR _4517_/D sky130_fd_sc_hd__a22o_1
XFILLER_66_421 VGND VGND VPWR VPWR sky130_fd_sc_hd__decap_6
X_2213_ hold75/A VGND VGND VPWR VPWR _2495_/A sky130_fd_sc_hd__inv_2
XFILLER_26_307 VGND VGND VPWR VPWR sky130_fd_sc_hd__fill_1
XFILLER_38_189 VGND VGND VPWR VPWR sky130_fd_sc_hd__decap_6
XFILLER_53_126 VGND VGND VPWR VPWR sky130_fd_sc_hd__decap_6
XTAP_TAPCELL_ROW_52_806 VGND VPWR sky130_fd_sc_hd__tapvpwrvgnd_1
X_2977_ _4508_/Q _2977_/B VGND VGND VPWR VPWR _3027_/A sky130_fd_sc_hd__xnor2_1
XTAP_TAPCELL_ROW_60_894 VGND VPWR sky130_fd_sc_hd__tapvpwrvgnd_1
XTAP_TAPCELL_ROW_32_585 VGND VPWR sky130_fd_sc_hd__tapvpwrvgnd_1
X_4716_ _4716_/CLK _4716_/D fanout163/X VGND VGND VPWR VPWR _4716_/Q sky130_fd_sc_hd__dfrtp_1
X_4647_ _4679_/CLK _4647_/D fanout139/X VGND VGND VPWR VPWR _4647_/Q sky130_fd_sc_hd__dfrtp_1
XFILLER_30_27 VGND VGND VPWR VPWR sky130_fd_sc_hd__fill_1
X_4578_ _4756_/CLK _4578_/D fanout134/X VGND VGND VPWR VPWR _4578_/Q sky130_fd_sc_hd__dfrtp_1
X_3529_ _3529_/A _3650_/A VGND VGND VPWR VPWR _3530_/B sky130_fd_sc_hd__xnor2_2
XFILLER_76_229 VGND VGND VPWR VPWR sky130_fd_sc_hd__decap_4
XTAP_TAPCELL_ROW_68_983 VGND VPWR sky130_fd_sc_hd__tapvpwrvgnd_1
XTAP_TAPCELL_ROW_4_277 VGND VPWR sky130_fd_sc_hd__tapvpwrvgnd_1
XFILLER_84_295 VGND VGND VPWR VPWR sky130_fd_sc_hd__fill_1
XFILLER_55_57 VPWR VGND VPWR VGND sky130_ef_sc_hd__decap_12
XTAP_TAPCELL_ROW_80_1116 VGND VPWR sky130_fd_sc_hd__tapvpwrvgnd_1
XFILLER_13_535 VPWR VGND VPWR VGND sky130_ef_sc_hd__decap_12
XFILLER_13_579 VGND VGND VPWR VPWR sky130_fd_sc_hd__decap_4
XFILLER_4_222 VGND VGND VPWR VPWR sky130_fd_sc_hd__decap_6
XTAP_TAPCELL_ROW_78_1089 VGND VPWR sky130_fd_sc_hd__tapvpwrvgnd_1
XTAP_TAPCELL_ROW_91_1234 VGND VPWR sky130_fd_sc_hd__tapvpwrvgnd_1
XFILLER_96_53 VPWR VGND VPWR VGND sky130_ef_sc_hd__decap_12
XFILLER_95_505 VPWR VGND VPWR VGND sky130_ef_sc_hd__decap_12
XFILLER_67_229 VGND VGND VPWR VPWR sky130_fd_sc_hd__fill_1
XFILLER_96_97 VPWR VGND VPWR VGND sky130_ef_sc_hd__decap_12
XFILLER_48_421 VPWR VGND VPWR VGND sky130_ef_sc_hd__decap_12
Xhold80 hold80/A VGND VGND VPWR VPWR hold80/X sky130_fd_sc_hd__dlygate4sd3_1
XFILLER_75_273 VGND VGND VPWR VPWR sky130_fd_sc_hd__decap_6
XFILLER_36_605 VGND VGND VPWR VPWR sky130_fd_sc_hd__fill_1
Xhold91 hold91/A VGND VGND VPWR VPWR hold91/X sky130_fd_sc_hd__dlygate4sd3_1
XFILLER_48_498 VGND VGND VPWR VPWR sky130_fd_sc_hd__decap_6
XFILLER_90_265 VGND VGND VPWR VPWR sky130_fd_sc_hd__fill_2
XFILLER_90_243 VGND VGND VPWR VPWR sky130_fd_sc_hd__decap_8
XFILLER_51_608 VGND VGND VPWR VPWR sky130_fd_sc_hd__decap_8
XFILLER_16_362 VGND VGND VPWR VPWR sky130_fd_sc_hd__fill_2
X_2900_ _2900_/A _2900_/B VGND VGND VPWR VPWR _3696_/A sky130_fd_sc_hd__xor2_4
X_3880_ _3880_/A _3988_/A VGND VGND VPWR VPWR _3882_/B sky130_fd_sc_hd__xnor2_1
XTAP_TAPCELL_ROW_100_1330 VGND VPWR sky130_fd_sc_hd__tapvpwrvgnd_1
X_2831_ _2831_/A _2831_/B _2831_/C _2734_/A VGND VGND VPWR VPWR _2834_/B sky130_fd_sc_hd__or4b_2
XFILLER_77_3 VPWR VGND VPWR VGND sky130_ef_sc_hd__decap_12
X_2762_ hold68/A _4599_/Q hold71/A _4663_/Q _2746_/S _2837_/S1 VGND VGND VPWR VPWR
+ _2810_/B sky130_fd_sc_hd__mux4_2
X_4501_ _4501_/CLK _4501_/D fanout130/X VGND VGND VPWR VPWR _4501_/Q sky130_fd_sc_hd__dfrtp_4
X_4432_ _4519_/CLK _4432_/D fanout170/X VGND VGND VPWR VPWR _4432_/Q sky130_fd_sc_hd__dfrtp_1
X_2693_ _4743_/Q _2694_/B VGND VGND VPWR VPWR _2693_/Y sky130_fd_sc_hd__nand2_1
XFILLER_104_109 VPWR VGND VPWR VGND sky130_ef_sc_hd__decap_12
XFILLER_98_321 VPWR VGND VPWR VGND sky130_ef_sc_hd__decap_12
X_4363_ _4679_/CLK _4363_/D fanout138/X VGND VGND VPWR VPWR _4363_/Q sky130_fd_sc_hd__dfrtp_4
XFILLER_98_365 VPWR VGND VPWR VGND sky130_ef_sc_hd__decap_12
X_4294_ _4485_/Q _4294_/B VGND VGND VPWR VPWR _4294_/Y sky130_fd_sc_hd__xnor2_1
X_3314_ _3298_/A _3298_/B _3295_/X VGND VGND VPWR VPWR _3315_/B sky130_fd_sc_hd__a21o_1
X_3245_ _3243_/A _3243_/B _3241_/X VGND VGND VPWR VPWR _3255_/A sky130_fd_sc_hd__a21o_1
XFILLER_39_421 VGND VGND VPWR VPWR sky130_fd_sc_hd__decap_6
XFILLER_39_432 VGND VGND VPWR VPWR sky130_fd_sc_hd__decap_3
X_3176_ _4763_/Q _3176_/B VGND VGND VPWR VPWR _3177_/B sky130_fd_sc_hd__or2_1
XFILLER_66_251 VGND VGND VPWR VPWR sky130_fd_sc_hd__fill_1
XFILLER_66_273 VGND VGND VPWR VPWR sky130_fd_sc_hd__fill_1
XTAP_TAPCELL_ROW_65_942 VGND VPWR sky130_fd_sc_hd__tapvpwrvgnd_1
XTAP_TAPCELL_ROW_1_247 VGND VPWR sky130_fd_sc_hd__tapvpwrvgnd_1
XFILLER_25_27 VPWR VGND VPWR VGND sky130_ef_sc_hd__decap_12
XTAP_TAPCELL_ROW_37_644 VGND VPWR sky130_fd_sc_hd__tapvpwrvgnd_1
XFILLER_34_170 VGND VGND VPWR VPWR sky130_fd_sc_hd__decap_4
XFILLER_22_365 VPWR VGND VPWR VGND sky130_ef_sc_hd__decap_12
XFILLER_22_398 VGND VGND VPWR VPWR sky130_fd_sc_hd__fill_2
XFILLER_41_15 VPWR VGND VPWR VGND sky130_ef_sc_hd__decap_12
XTAP_TAPCELL_ROW_9_336 VGND VPWR sky130_fd_sc_hd__tapvpwrvgnd_1
XFILLER_77_505 VPWR VGND VPWR VGND sky130_ef_sc_hd__decap_12
XFILLER_106_41 VPWR VGND VPWR VGND sky130_ef_sc_hd__decap_12
XFILLER_106_85 VPWR VGND VPWR VGND sky130_ef_sc_hd__decap_12
XFILLER_18_627 VGND VGND VPWR VPWR sky130_fd_sc_hd__decap_8
XFILLER_72_232 VPWR VGND VPWR VGND sky130_ef_sc_hd__decap_12
XFILLER_72_287 VGND VGND VPWR VPWR sky130_fd_sc_hd__fill_1
XFILLER_82_99 VGND VGND VPWR VPWR sky130_fd_sc_hd__decap_3
XFILLER_82_77 VGND VGND VPWR VPWR sky130_fd_sc_hd__decap_6
Xclkbuf_leaf_52_clk clkload4/A VGND VGND VPWR VPWR _4527_/CLK sky130_fd_sc_hd__clkbuf_8
XFILLER_41_630 VGND VGND VPWR VPWR sky130_fd_sc_hd__decap_6
XFILLER_13_387 VGND VGND VPWR VPWR sky130_fd_sc_hd__decap_4
XFILLER_40_195 VGND VGND VPWR VPWR sky130_fd_sc_hd__fill_1
XFILLER_95_324 VPWR VGND VPWR VGND sky130_ef_sc_hd__decap_12
XFILLER_48_240 VPWR VGND VPWR VGND sky130_ef_sc_hd__decap_12
X_3030_ _4509_/Q _2999_/B _3000_/A VGND VGND VPWR VPWR _3030_/Y sky130_fd_sc_hd__a21boi_1
XFILLER_91_541 VPWR VGND VPWR VGND sky130_ef_sc_hd__decap_12
XFILLER_24_608 VGND VGND VPWR VPWR sky130_fd_sc_hd__decap_3
XFILLER_91_585 VPWR VGND VPWR VGND sky130_ef_sc_hd__decap_12
XFILLER_63_276 VGND VGND VPWR VPWR sky130_fd_sc_hd__decap_4
XTAP_TAPCELL_ROW_62_912 VGND VPWR sky130_fd_sc_hd__tapvpwrvgnd_1
XTAP_TAPCELL_ROW_34_603 VGND VPWR sky130_fd_sc_hd__tapvpwrvgnd_1
X_3932_ _3847_/A _3889_/A _3868_/B VGND VGND VPWR VPWR _3932_/Y sky130_fd_sc_hd__o21bai_1
Xclkbuf_leaf_43_clk clkload4/A VGND VGND VPWR VPWR _4735_/CLK sky130_fd_sc_hd__clkbuf_8
XFILLER_16_192 VGND VGND VPWR VPWR sky130_fd_sc_hd__decap_4
XFILLER_51_449 VGND VGND VPWR VPWR sky130_fd_sc_hd__decap_6
X_3863_ _3863_/A _3863_/B VGND VGND VPWR VPWR _3864_/B sky130_fd_sc_hd__xnor2_1
XTAP_TAPCELL_ROW_14_382 VGND VPWR sky130_fd_sc_hd__tapvpwrvgnd_1
X_2814_ _2841_/B _2814_/B VGND VGND VPWR VPWR _2825_/A sky130_fd_sc_hd__nand2_1
XTAP_TAPCELL_ROW_42_691 VGND VPWR sky130_fd_sc_hd__tapvpwrvgnd_1
X_3794_ _3791_/A _3813_/A2 _3793_/Y _3794_/B2 VGND VGND VPWR VPWR _4544_/D sky130_fd_sc_hd__a22o_1
X_2745_ _2744_/X _2747_/A VGND VGND VPWR VPWR _2749_/B sky130_fd_sc_hd__nand2b_1
X_2676_ _2710_/A _2676_/B VGND VGND VPWR VPWR _2684_/A sky130_fd_sc_hd__xnor2_1
XFILLER_105_429 VPWR VGND VPWR VGND sky130_ef_sc_hd__decap_12
X_4415_ _4501_/CLK _4415_/D fanout130/X VGND VGND VPWR VPWR hold21/A sky130_fd_sc_hd__dfrtp_1
X_4346_ _4758_/Q _4354_/A2 _3774_/A _4354_/B2 VGND VGND VPWR VPWR _4758_/D sky130_fd_sc_hd__a22o_1
XFILLER_59_505 VPWR VGND VPWR VGND sky130_ef_sc_hd__decap_12
XFILLER_98_195 VGND VGND VPWR VPWR sky130_fd_sc_hd__fill_1
X_4277_ _4405_/Q hold27/A _4421_/Q _4429_/Q _4319_/S0 _2249_/B VGND VGND VPWR VPWR
+ _4278_/A sky130_fd_sc_hd__mux4_1
X_3228_ _3226_/A _3226_/B _3223_/X VGND VGND VPWR VPWR _3243_/A sky130_fd_sc_hd__a21o_1
XFILLER_100_189 VGND VGND VPWR VPWR sky130_fd_sc_hd__decap_6
X_3159_ _3159_/A _3159_/B _3159_/C VGND VGND VPWR VPWR _3160_/B sky130_fd_sc_hd__nand3_1
XFILLER_36_15 VPWR VGND VPWR VGND sky130_ef_sc_hd__decap_12
XFILLER_54_221 VGND VGND VPWR VPWR sky130_fd_sc_hd__decap_4
XFILLER_42_449 VGND VGND VPWR VPWR sky130_fd_sc_hd__fill_2
Xclkbuf_leaf_34_clk clkload6/A VGND VGND VPWR VPWR _4716_/CLK sky130_fd_sc_hd__clkbuf_8
XFILLER_22_162 VGND VGND VPWR VPWR sky130_fd_sc_hd__decap_6
XTAP_TAPCELL_ROW_75_1059 VGND VPWR sky130_fd_sc_hd__tapvpwrvgnd_1
XFILLER_7_3 VPWR VGND VPWR VGND sky130_ef_sc_hd__decap_12
XFILLER_2_545 VGND VGND VPWR VPWR sky130_fd_sc_hd__decap_6
XFILLER_77_55 VGND VGND VPWR VPWR sky130_fd_sc_hd__fill_1
XFILLER_2_589 VPWR VGND VPWR VGND sky130_ef_sc_hd__decap_12
XFILLER_73_541 VPWR VGND VPWR VGND sky130_ef_sc_hd__decap_12
XTAP_TAPCELL_ROW_86_1177 VGND VPWR sky130_fd_sc_hd__tapvpwrvgnd_1
XFILLER_73_585 VPWR VGND VPWR VGND sky130_ef_sc_hd__decap_12
Xclkbuf_leaf_25_clk clkload5/A VGND VGND VPWR VPWR _4552_/CLK sky130_fd_sc_hd__clkbuf_8
XFILLER_26_490 VGND VGND VPWR VPWR sky130_fd_sc_hd__fill_1
XFILLER_33_449 VGND VGND VPWR VPWR sky130_fd_sc_hd__fill_1
XFILLER_60_224 VPWR VGND VPWR VGND sky130_ef_sc_hd__decap_12
XFILLER_13_173 VGND VGND VPWR VPWR sky130_fd_sc_hd__fill_1
XFILLER_41_482 VPWR VGND VPWR VGND sky130_ef_sc_hd__decap_12
XFILLER_13_195 VGND VGND VPWR VPWR sky130_fd_sc_hd__fill_2
XFILLER_9_155 VGND VGND VPWR VPWR sky130_fd_sc_hd__decap_4
XTAP_TAPCELL_ROW_11_352 VGND VPWR sky130_fd_sc_hd__tapvpwrvgnd_1
X_2530_ _2534_/A2 _2528_/Y _2529_/Y _2535_/A2 hold61/X VGND VGND VPWR VPWR _4470_/D
+ sky130_fd_sc_hd__a32o_1
XTAP_TAPCELL_ROW_97_1295 VGND VPWR sky130_fd_sc_hd__tapvpwrvgnd_1
X_2461_ _2461_/A _2461_/B VGND VGND VPWR VPWR _2467_/C sky130_fd_sc_hd__nor2_1
X_4200_ _4201_/A _4201_/B VGND VGND VPWR VPWR _4200_/Y sky130_fd_sc_hd__nand2_1
XFILLER_68_313 VGND VGND VPWR VPWR sky130_fd_sc_hd__fill_1
X_2392_ hold222/X _2395_/A2 _2395_/B1 _4493_/Q VGND VGND VPWR VPWR _2392_/X sky130_fd_sc_hd__a22o_1
X_4131_ _4140_/B _4131_/B _4140_/D _4131_/D VGND VGND VPWR VPWR _4139_/S sky130_fd_sc_hd__and4b_4
X_4062_ _4134_/A1 hold199/X _4067_/S VGND VGND VPWR VPWR _4599_/D sky130_fd_sc_hd__mux2_1
XFILLER_83_349 VPWR VGND VPWR VGND sky130_ef_sc_hd__decap_12
X_3013_ _3013_/A _3013_/B VGND VGND VPWR VPWR _3014_/B sky130_fd_sc_hd__or2_1
XTAP_TAPCELL_ROW_19_441 VGND VPWR sky130_fd_sc_hd__tapvpwrvgnd_1
XTAP_TAPCELL_ROW_47_750 VGND VPWR sky130_fd_sc_hd__tapvpwrvgnd_1
XFILLER_91_360 VGND VGND VPWR VPWR sky130_fd_sc_hd__decap_4
XFILLER_91_393 VPWR VGND VPWR VGND sky130_ef_sc_hd__decap_12
Xclkbuf_leaf_16_clk clkload3/A VGND VGND VPWR VPWR _4761_/CLK sky130_fd_sc_hd__clkbuf_8
X_3915_ hold95/A _4585_/Q _4681_/Q hold44/A _3915_/S0 _3915_/S1 VGND VGND VPWR VPWR
+ _3917_/B sky130_fd_sc_hd__mux4_1
XFILLER_20_600 VGND VGND VPWR VPWR sky130_fd_sc_hd__fill_1
XFILLER_51_279 VGND VGND VPWR VPWR sky130_fd_sc_hd__fill_1
XFILLER_32_493 VGND VGND VPWR VPWR sky130_fd_sc_hd__fill_2
X_3846_ hold14/X _3979_/B2 _3843_/X _3845_/Y VGND VGND VPWR VPWR _4546_/D sky130_fd_sc_hd__a22o_1
X_3777_ _3778_/A _3778_/C VGND VGND VPWR VPWR _3779_/B sky130_fd_sc_hd__nand2_1
X_2728_ _2681_/Y _2726_/X _2724_/Y _2820_/A VGND VGND VPWR VPWR _2728_/X sky130_fd_sc_hd__a211o_1
XFILLER_105_237 VPWR VGND VPWR VGND sky130_ef_sc_hd__decap_12
X_2659_ _2660_/B VGND VGND VPWR VPWR _2659_/Y sky130_fd_sc_hd__inv_2
Xfanout112 _2249_/B VGND VGND VPWR VPWR _2427_/B sky130_fd_sc_hd__clkbuf_4
Xfanout101 _4736_/Q VGND VGND VPWR VPWR _2746_/S sky130_fd_sc_hd__buf_4
Xfanout134 fanout135/X VGND VGND VPWR VPWR fanout134/X sky130_fd_sc_hd__clkbuf_4
Xfanout156 fanout157/X VGND VGND VPWR VPWR fanout156/X sky130_fd_sc_hd__clkbuf_4
Xfanout123 fanout128/X VGND VGND VPWR VPWR fanout123/X sky130_fd_sc_hd__clkbuf_4
X_4329_ _2325_/C _3373_/A _4331_/A2 _4741_/Q VGND VGND VPWR VPWR _4741_/D sky130_fd_sc_hd__a2bb2o_1
Xfanout145 fanout173/X VGND VGND VPWR VPWR fanout145/X sky130_fd_sc_hd__clkbuf_4
Xfanout167 fanout171/X VGND VGND VPWR VPWR fanout167/X sky130_fd_sc_hd__clkbuf_4
XFILLER_47_69 VPWR VGND VPWR VGND sky130_ef_sc_hd__decap_12
XFILLER_27_232 VGND VGND VPWR VPWR sky130_fd_sc_hd__fill_2
XFILLER_27_254 VGND VGND VPWR VPWR sky130_fd_sc_hd__fill_2
XFILLER_55_585 VPWR VGND VPWR VGND sky130_ef_sc_hd__decap_12
XFILLER_70_533 VPWR VGND VPWR VGND sky130_ef_sc_hd__decap_12
XFILLER_63_57 VPWR VGND VPWR VGND sky130_ef_sc_hd__decap_12
XFILLER_42_235 VPWR VGND VPWR VGND sky130_ef_sc_hd__decap_12
XFILLER_30_419 VGND VGND VPWR VPWR sky130_fd_sc_hd__fill_1
XFILLER_50_290 VPWR VGND VPWR VGND sky130_ef_sc_hd__decap_12
XFILLER_12_83 VGND VGND VPWR VPWR sky130_fd_sc_hd__fill_1
XFILLER_88_65 VPWR VGND VPWR VGND sky130_ef_sc_hd__decap_12
XFILLER_38_519 VPWR VGND VPWR VGND sky130_ef_sc_hd__decap_12
XFILLER_92_135 VGND VGND VPWR VPWR sky130_fd_sc_hd__decap_4
XFILLER_18_232 VGND VGND VPWR VPWR sky130_fd_sc_hd__decap_3
XFILLER_73_371 VGND VGND VPWR VPWR sky130_fd_sc_hd__decap_3
XFILLER_18_265 VGND VGND VPWR VPWR sky130_fd_sc_hd__decap_4
XTAP_TAPCELL_ROW_16_411 VGND VPWR sky130_fd_sc_hd__tapvpwrvgnd_1
XTAP_TAPCELL_ROW_44_720 VGND VPWR sky130_fd_sc_hd__tapvpwrvgnd_1
XFILLER_33_268 VGND VGND VPWR VPWR sky130_fd_sc_hd__decap_8
XFILLER_14_460 VGND VGND VPWR VPWR sky130_fd_sc_hd__decap_6
X_3700_ _3720_/A _3720_/B _3674_/A _3674_/B VGND VGND VPWR VPWR _3708_/A sky130_fd_sc_hd__o22a_1
XTAP_TAPCELL_ROW_99_1324 VGND VPWR sky130_fd_sc_hd__tapvpwrvgnd_1
X_4680_ _4684_/CLK _4680_/D fanout139/X VGND VGND VPWR VPWR hold76/A sky130_fd_sc_hd__dfrtp_1
X_3631_ _3628_/A _3594_/Y _3593_/X VGND VGND VPWR VPWR _3631_/Y sky130_fd_sc_hd__a21oi_1
X_3562_ _3633_/A _3530_/B _3542_/B _3648_/A VGND VGND VPWR VPWR _3562_/X sky130_fd_sc_hd__a22o_1
X_2513_ _2518_/C _2512_/Y _4465_/Q _2526_/B1 VGND VGND VPWR VPWR _4465_/D sky130_fd_sc_hd__a2bb2o_1
X_3493_ _3554_/B2 _3491_/X _3492_/Y _2558_/B _4532_/Q VGND VGND VPWR VPWR _4532_/D
+ sky130_fd_sc_hd__a32o_1
X_2444_ _4445_/Q _2445_/B VGND VGND VPWR VPWR _2449_/B sky130_fd_sc_hd__nand2_1
Xclkbuf_leaf_5_clk clkload1/A VGND VGND VPWR VPWR _4750_/CLK sky130_fd_sc_hd__clkbuf_8
X_2375_ hold34/X _2375_/A2 _2375_/B1 _4540_/Q VGND VGND VPWR VPWR _4390_/D sky130_fd_sc_hd__a22o_1
X_4114_ hold148/X _4008_/X _4121_/S VGND VGND VPWR VPWR _4645_/D sky130_fd_sc_hd__mux2_1
XFILLER_84_625 VPWR VGND VPWR VGND sky130_ef_sc_hd__decap_12
XFILLER_83_113 VPWR VGND VPWR VGND sky130_ef_sc_hd__decap_12
XFILLER_83_157 VGND VGND VPWR VPWR sky130_fd_sc_hd__decap_8
X_4045_ _4135_/A1 hold204/X _4049_/S VGND VGND VPWR VPWR _4584_/D sky130_fd_sc_hd__mux2_1
XFILLER_17_39 VPWR VGND VPWR VGND sky130_ef_sc_hd__decap_12
XFILLER_52_511 VGND VGND VPWR VPWR sky130_fd_sc_hd__fill_2
XFILLER_12_419 VGND VGND VPWR VPWR sky130_fd_sc_hd__fill_1
XFILLER_24_279 VPWR VGND VPWR VGND sky130_ef_sc_hd__decap_12
XFILLER_33_27 VPWR VGND VPWR VGND sky130_ef_sc_hd__decap_12
X_3829_ _3787_/A _3807_/A _3828_/B _3828_/A VGND VGND VPWR VPWR _3829_/X sky130_fd_sc_hd__o211a_1
XTAP_TAPCELL_ROW_22_469 VGND VPWR sky130_fd_sc_hd__tapvpwrvgnd_1
XTAP_TAPCELL_ROW_50_778 VGND VPWR sky130_fd_sc_hd__tapvpwrvgnd_1
XFILLER_106_513 VPWR VGND VPWR VGND sky130_ef_sc_hd__decap_12
XFILLER_4_629 VGND VGND VPWR VPWR sky130_fd_sc_hd__decap_8
XFILLER_106_557 VPWR VGND VPWR VGND sky130_ef_sc_hd__decap_12
XTAP_TAPCELL_ROW_72_1029 VGND VPWR sky130_fd_sc_hd__tapvpwrvgnd_1
XFILLER_101_273 VGND VGND VPWR VPWR sky130_fd_sc_hd__decap_6
XFILLER_87_485 VPWR VGND VPWR VGND sky130_ef_sc_hd__decap_12
XTAP_TAPCELL_ROW_58_867 VGND VPWR sky130_fd_sc_hd__tapvpwrvgnd_1
XFILLER_43_522 VGND VGND VPWR VPWR sky130_fd_sc_hd__fill_1
XTAP_TAPCELL_ROW_83_1147 VGND VPWR sky130_fd_sc_hd__tapvpwrvgnd_1
XFILLER_43_555 VGND VGND VPWR VPWR sky130_fd_sc_hd__fill_1
XFILLER_70_374 VGND VGND VPWR VPWR sky130_fd_sc_hd__decap_6
XFILLER_30_227 VGND VGND VPWR VPWR sky130_fd_sc_hd__decap_8
XFILLER_43_599 VGND VGND VPWR VPWR sky130_fd_sc_hd__fill_2
XFILLER_90_77 VGND VGND VPWR VPWR sky130_fd_sc_hd__decap_6
XTAP_TAPCELL_ROW_94_1265 VGND VPWR sky130_fd_sc_hd__tapvpwrvgnd_1
XFILLER_97_205 VPWR VGND VPWR VGND sky130_ef_sc_hd__decap_12
XFILLER_97_249 VPWR VGND VPWR VGND sky130_ef_sc_hd__decap_12
XFILLER_66_625 VPWR VGND VPWR VGND sky130_ef_sc_hd__decap_12
XFILLER_38_327 VGND VGND VPWR VPWR sky130_fd_sc_hd__fill_1
XFILLER_81_617 VPWR VGND VPWR VGND sky130_ef_sc_hd__decap_12
XFILLER_34_533 VGND VGND VPWR VPWR sky130_fd_sc_hd__decap_3
XFILLER_0_97 VPWR VGND VPWR VGND sky130_ef_sc_hd__decap_12
XTAP_TAPCELL_ROW_103_1361 VGND VPWR sky130_fd_sc_hd__tapvpwrvgnd_1
X_2993_ _2992_/B _2992_/C _4541_/Q VGND VGND VPWR VPWR _2994_/B sky130_fd_sc_hd__a21oi_1
XFILLER_9_51 VGND VGND VPWR VPWR sky130_fd_sc_hd__decap_4
X_4732_ _4734_/CLK _4732_/D fanout147/X VGND VGND VPWR VPWR _4732_/Q sky130_fd_sc_hd__dfrtp_2
X_4663_ clkload7/A _4663_/D fanout121/X VGND VGND VPWR VPWR _4663_/Q sky130_fd_sc_hd__dfrtp_1
X_3614_ _3583_/A _3610_/B _3610_/A VGND VGND VPWR VPWR _3614_/X sky130_fd_sc_hd__a21bo_1
X_4594_ _4661_/CLK _4594_/D fanout121/X VGND VGND VPWR VPWR _4594_/Q sky130_fd_sc_hd__dfrtp_1
X_3545_ hold73/A hold78/A _4666_/Q _4602_/Q _3599_/S0 _3522_/B VGND VGND VPWR VPWR
+ _3546_/B sky130_fd_sc_hd__mux4_2
XFILLER_103_505 VPWR VGND VPWR VGND sky130_ef_sc_hd__decap_12
XFILLER_0_109 VGND VGND VPWR VPWR sky130_fd_sc_hd__decap_3
X_3476_ _3476_/A _3476_/B VGND VGND VPWR VPWR _3480_/A sky130_fd_sc_hd__and2_1
X_2427_ _2427_/A _2427_/B _2427_/C VGND VGND VPWR VPWR _2427_/X sky130_fd_sc_hd__and3_1
X_2358_ hold59/X _2395_/A2 _2395_/B1 _4523_/Q VGND VGND VPWR VPWR _4373_/D sky130_fd_sc_hd__a22o_1
XFILLER_28_27 VGND VGND VPWR VPWR sky130_fd_sc_hd__fill_1
XFILLER_84_433 VPWR VGND VPWR VGND sky130_ef_sc_hd__decap_12
X_2289_ _4693_/Q _2459_/A VGND VGND VPWR VPWR _2289_/Y sky130_fd_sc_hd__nand2_1
XFILLER_84_477 VPWR VGND VPWR VGND sky130_ef_sc_hd__decap_12
X_4028_ _4734_/Q _4030_/B VGND VGND VPWR VPWR _4028_/X sky130_fd_sc_hd__and2_2
XFILLER_56_179 VGND VGND VPWR VPWR sky130_fd_sc_hd__decap_4
XTAP_TAPCELL_ROW_27_528 VGND VPWR sky130_fd_sc_hd__tapvpwrvgnd_1
XFILLER_37_393 VGND VGND VPWR VPWR sky130_fd_sc_hd__decap_4
XFILLER_44_15 VPWR VGND VPWR VGND sky130_ef_sc_hd__decap_12
XTAP_TAPCELL_ROW_55_837 VGND VPWR sky130_fd_sc_hd__tapvpwrvgnd_1
XFILLER_25_555 VGND VGND VPWR VPWR sky130_fd_sc_hd__decap_4
XFILLER_52_330 VGND VGND VPWR VPWR sky130_fd_sc_hd__decap_4
XFILLER_40_525 VGND VGND VPWR VPWR sky130_fd_sc_hd__decap_6
XFILLER_40_569 VGND VGND VPWR VPWR sky130_fd_sc_hd__fill_1
XFILLER_100_65 VPWR VGND VPWR VGND sky130_ef_sc_hd__decap_12
XFILLER_4_415 VGND VGND VPWR VPWR sky130_fd_sc_hd__decap_4
XFILLER_107_3 VPWR VGND VPWR VGND sky130_ef_sc_hd__decap_12
XFILLER_106_321 VPWR VGND VPWR VGND sky130_ef_sc_hd__decap_12
XFILLER_106_365 VPWR VGND VPWR VGND sky130_ef_sc_hd__decap_12
XFILLER_47_113 VGND VGND VPWR VPWR sky130_fd_sc_hd__fill_1
XFILLER_48_625 VPWR VGND VPWR VGND sky130_ef_sc_hd__decap_12
XFILLER_85_55 VGND VGND VPWR VPWR sky130_fd_sc_hd__fill_1
XFILLER_75_455 VPWR VGND VPWR VGND sky130_ef_sc_hd__decap_12
XFILLER_63_617 VPWR VGND VPWR VGND sky130_ef_sc_hd__decap_12
XFILLER_35_319 VGND VGND VPWR VPWR sky130_fd_sc_hd__decap_4
XFILLER_16_533 VGND VGND VPWR VPWR sky130_fd_sc_hd__decap_8
XFILLER_90_469 VGND VGND VPWR VPWR sky130_fd_sc_hd__decap_6
Xhold209 _2406_/X VGND VGND VPWR VPWR _4421_/D sky130_fd_sc_hd__dlygate4sd3_1
X_3330_ _3310_/A _3310_/B _3307_/X VGND VGND VPWR VPWR _3331_/B sky130_fd_sc_hd__a21o_1
XFILLER_98_525 VGND VGND VPWR VPWR sky130_fd_sc_hd__decap_6
XFILLER_98_569 VPWR VGND VPWR VGND sky130_ef_sc_hd__decap_12
X_3261_ _4740_/Q _4741_/Q _3339_/B _4742_/Q VGND VGND VPWR VPWR _3409_/B sky130_fd_sc_hd__o31a_1
XFILLER_78_271 VGND VGND VPWR VPWR sky130_fd_sc_hd__decap_8
X_3192_ _3987_/A VGND VGND VPWR VPWR _3192_/Y sky130_fd_sc_hd__inv_2
XFILLER_22_3 VPWR VGND VPWR VGND sky130_ef_sc_hd__decap_12
X_2212_ _4461_/Q VGND VGND VPWR VPWR _2498_/A sky130_fd_sc_hd__inv_2
XFILLER_66_477 VPWR VGND VPWR VGND sky130_ef_sc_hd__decap_12
XFILLER_19_371 VGND VGND VPWR VPWR sky130_fd_sc_hd__decap_3
XTAP_TAPCELL_ROW_52_807 VGND VPWR sky130_fd_sc_hd__tapvpwrvgnd_1
XFILLER_61_193 VGND VGND VPWR VPWR sky130_fd_sc_hd__fill_2
XFILLER_14_29 VPWR VGND VPWR VGND sky130_ef_sc_hd__decap_12
X_2976_ _4508_/Q _2977_/B VGND VGND VPWR VPWR _3000_/A sky130_fd_sc_hd__nand2_1
XTAP_TAPCELL_ROW_60_895 VGND VPWR sky130_fd_sc_hd__tapvpwrvgnd_1
XTAP_TAPCELL_ROW_32_586 VGND VPWR sky130_fd_sc_hd__tapvpwrvgnd_1
X_4715_ _4715_/CLK _4715_/D fanout163/X VGND VGND VPWR VPWR _4715_/Q sky130_fd_sc_hd__dfrtp_1
X_4646_ _4758_/CLK _4646_/D fanout140/X VGND VGND VPWR VPWR hold80/A sky130_fd_sc_hd__dfrtp_1
X_4577_ _4756_/CLK _4577_/D fanout136/X VGND VGND VPWR VPWR _4577_/Q sky130_fd_sc_hd__dfrtp_1
XFILLER_89_503 VGND VGND VPWR VPWR sky130_fd_sc_hd__fill_1
X_3528_ _3482_/X _3484_/X _3499_/Y _3527_/X VGND VGND VPWR VPWR _3532_/B sky130_fd_sc_hd__a31oi_2
XFILLER_39_15 VPWR VGND VPWR VGND sky130_ef_sc_hd__decap_12
XFILLER_103_335 VGND VGND VPWR VPWR sky130_fd_sc_hd__fill_1
X_3459_ _3459_/A _3459_/B VGND VGND VPWR VPWR _3460_/B sky130_fd_sc_hd__nand2_1
XFILLER_57_400 VGND VGND VPWR VPWR sky130_fd_sc_hd__decap_3
XFILLER_29_113 VGND VGND VPWR VPWR sky130_fd_sc_hd__decap_6
XTAP_TAPCELL_ROW_68_984 VGND VPWR sky130_fd_sc_hd__tapvpwrvgnd_1
XTAP_TAPCELL_ROW_4_278 VGND VPWR sky130_fd_sc_hd__tapvpwrvgnd_1
XFILLER_17_308 VPWR VGND VPWR VGND sky130_ef_sc_hd__decap_12
XFILLER_45_617 VPWR VGND VPWR VGND sky130_ef_sc_hd__decap_12
XFILLER_55_69 VPWR VGND VPWR VGND sky130_ef_sc_hd__decap_12
XFILLER_25_330 VGND VGND VPWR VPWR sky130_fd_sc_hd__decap_6
XTAP_TAPCELL_ROW_80_1117 VGND VPWR sky130_fd_sc_hd__tapvpwrvgnd_1
XFILLER_13_547 VGND VGND VPWR VPWR sky130_fd_sc_hd__fill_2
XFILLER_71_57 VPWR VGND VPWR VGND sky130_ef_sc_hd__decap_12
XTAP_TAPCELL_ROW_91_1235 VGND VPWR sky130_fd_sc_hd__tapvpwrvgnd_1
XFILLER_20_83 VGND VGND VPWR VPWR sky130_fd_sc_hd__fill_1
XFILLER_106_195 VGND VGND VPWR VPWR sky130_fd_sc_hd__fill_1
XFILLER_96_65 VPWR VGND VPWR VGND sky130_ef_sc_hd__decap_12
XFILLER_95_517 VPWR VGND VPWR VGND sky130_ef_sc_hd__decap_12
XFILLER_67_219 VGND VGND VPWR VPWR sky130_fd_sc_hd__decap_4
XFILLER_48_433 VGND VGND VPWR VPWR sky130_fd_sc_hd__fill_1
Xhold70 hold70/A VGND VGND VPWR VPWR hold70/X sky130_fd_sc_hd__dlygate4sd3_1
XFILLER_75_241 VPWR VGND VPWR VGND sky130_ef_sc_hd__decap_12
Xhold81 hold81/A VGND VGND VPWR VPWR hold81/X sky130_fd_sc_hd__dlygate4sd3_1
Xhold92 hold92/A VGND VGND VPWR VPWR hold92/X sky130_fd_sc_hd__dlygate4sd3_1
XFILLER_16_330 VPWR VGND VPWR VGND sky130_ef_sc_hd__decap_12
X_2830_ _4501_/Q _2799_/B _2829_/X VGND VGND VPWR VPWR _2830_/Y sky130_fd_sc_hd__o21ai_1
XTAP_TAPCELL_ROW_100_1331 VGND VPWR sky130_fd_sc_hd__tapvpwrvgnd_1
X_2761_ _4331_/B2 _3348_/B _3348_/C _4331_/A2 _4499_/Q VGND VGND VPWR VPWR _4499_/D
+ sky130_fd_sc_hd__a32o_1
X_2692_ _4564_/Q _4596_/Q hold90/A _4660_/Q _3257_/A _2747_/A VGND VGND VPWR VPWR
+ _2694_/B sky130_fd_sc_hd__mux4_2
X_4500_ _4501_/CLK _4500_/D fanout130/X VGND VGND VPWR VPWR _4500_/Q sky130_fd_sc_hd__dfrtp_1
X_4431_ _4542_/CLK _4431_/D fanout169/X VGND VGND VPWR VPWR _4431_/Q sky130_fd_sc_hd__dfrtp_1
XANTENNA_1 _4732_/Q VGND VGND VPWR VPWR sky130_fd_sc_hd__diode_2
XFILLER_6_41 VPWR VGND VPWR VGND sky130_ef_sc_hd__decap_12
XFILLER_6_85 VGND VGND VPWR VPWR sky130_fd_sc_hd__fill_2
X_4362_ _4671_/CLK _4362_/D fanout133/X VGND VGND VPWR VPWR _4362_/Q sky130_fd_sc_hd__dfrtp_1
XFILLER_98_333 VPWR VGND VPWR VGND sky130_ef_sc_hd__decap_12
X_3313_ _4524_/Q _3313_/B VGND VGND VPWR VPWR _3315_/A sky130_fd_sc_hd__xor2_1
X_4293_ _4318_/A _4292_/Y _4290_/Y _4439_/Q VGND VGND VPWR VPWR _4294_/B sky130_fd_sc_hd__a211o_1
XFILLER_98_377 VPWR VGND VPWR VGND sky130_ef_sc_hd__decap_12
X_3244_ _4520_/Q _4355_/A2 _3967_/B _3468_/A VGND VGND VPWR VPWR _4520_/D sky130_fd_sc_hd__o2bb2ai_1
X_3175_ _4763_/Q _3176_/B VGND VGND VPWR VPWR _3197_/A sky130_fd_sc_hd__nand2_1
XTAP_TAPCELL_ROW_1_248 VGND VPWR sky130_fd_sc_hd__tapvpwrvgnd_1
XFILLER_26_127 VGND VGND VPWR VPWR sky130_fd_sc_hd__fill_1
XTAP_TAPCELL_ROW_65_943 VGND VPWR sky130_fd_sc_hd__tapvpwrvgnd_1
XTAP_TAPCELL_ROW_37_634 VGND VPWR sky130_fd_sc_hd__tapvpwrvgnd_1
XFILLER_22_300 VGND VGND VPWR VPWR sky130_fd_sc_hd__decap_8
XFILLER_25_39 VPWR VGND VPWR VGND sky130_ef_sc_hd__decap_12
XFILLER_50_631 VGND VGND VPWR VPWR sky130_fd_sc_hd__decap_6
XFILLER_41_27 VPWR VGND VPWR VGND sky130_ef_sc_hd__decap_12
X_2959_ _4575_/Q _4607_/Q hold96/A _4671_/Q _4324_/S _3174_/S1 VGND VGND VPWR VPWR
+ _2961_/B sky130_fd_sc_hd__mux4_1
X_4629_ clkload7/A _4629_/D fanout124/X VGND VGND VPWR VPWR _4629_/Q sky130_fd_sc_hd__dfrtp_1
XTAP_TAPCELL_ROW_9_326 VGND VPWR sky130_fd_sc_hd__tapvpwrvgnd_1
XFILLER_1_215 VGND VGND VPWR VPWR sky130_fd_sc_hd__fill_2
XFILLER_106_53 VPWR VGND VPWR VGND sky130_ef_sc_hd__decap_12
XFILLER_77_517 VPWR VGND VPWR VGND sky130_ef_sc_hd__decap_12
XFILLER_106_97 VPWR VGND VPWR VGND sky130_ef_sc_hd__decap_12
XFILLER_85_561 VPWR VGND VPWR VGND sky130_ef_sc_hd__decap_12
XFILLER_57_252 VGND VGND VPWR VPWR sky130_fd_sc_hd__fill_2
XFILLER_72_244 VGND VGND VPWR VPWR sky130_fd_sc_hd__decap_8
XFILLER_72_277 VGND VGND VPWR VPWR sky130_fd_sc_hd__fill_2
XFILLER_60_406 VGND VGND VPWR VPWR sky130_fd_sc_hd__decap_3
XFILLER_40_141 VGND VGND VPWR VPWR sky130_fd_sc_hd__decap_6
XFILLER_9_337 VGND VGND VPWR VPWR sky130_fd_sc_hd__fill_2
XFILLER_0_281 VGND VGND VPWR VPWR sky130_fd_sc_hd__decap_8
XFILLER_0_292 VPWR VGND VPWR VGND sky130_ef_sc_hd__decap_12
XFILLER_63_211 VGND VGND VPWR VPWR sky130_fd_sc_hd__fill_1
XFILLER_91_553 VGND VGND VPWR VPWR sky130_fd_sc_hd__decap_6
XFILLER_91_597 VPWR VGND VPWR VGND sky130_ef_sc_hd__decap_12
XTAP_TAPCELL_ROW_62_913 VGND VPWR sky130_fd_sc_hd__tapvpwrvgnd_1
XTAP_TAPCELL_ROW_34_604 VGND VPWR sky130_fd_sc_hd__tapvpwrvgnd_1
X_3931_ _3931_/A _3931_/B VGND VGND VPWR VPWR _3931_/Y sky130_fd_sc_hd__nor2_1
X_3862_ _3862_/A _3862_/B VGND VGND VPWR VPWR _3863_/B sky130_fd_sc_hd__nand2_1
X_2813_ _2813_/A _2813_/B _2813_/C VGND VGND VPWR VPWR _2814_/B sky130_fd_sc_hd__nand3_1
X_3793_ _3838_/A _3793_/B VGND VGND VPWR VPWR _3793_/Y sky130_fd_sc_hd__xnor2_1
XTAP_TAPCELL_ROW_14_383 VGND VPWR sky130_fd_sc_hd__tapvpwrvgnd_1
XTAP_TAPCELL_ROW_42_692 VGND VPWR sky130_fd_sc_hd__tapvpwrvgnd_1
X_2744_ hold43/A _4662_/Q _2746_/S VGND VGND VPWR VPWR _2744_/X sky130_fd_sc_hd__mux2_1
X_2675_ _2648_/B _2674_/Y _2653_/B VGND VGND VPWR VPWR _2676_/B sky130_fd_sc_hd__o21ba_1
X_4414_ _4533_/CLK hold50/X fanout154/X VGND VGND VPWR VPWR hold49/A sky130_fd_sc_hd__dfrtp_1
X_4345_ _4757_/Q _4345_/A2 _3759_/A _4345_/B2 VGND VGND VPWR VPWR _4757_/D sky130_fd_sc_hd__a22o_1
XFILLER_98_141 VPWR VGND VPWR VGND sky130_ef_sc_hd__decap_12
XFILLER_59_517 VPWR VGND VPWR VGND sky130_ef_sc_hd__decap_12
XFILLER_86_325 VPWR VGND VPWR VGND sky130_ef_sc_hd__decap_12
X_4276_ _4283_/A _4276_/B VGND VGND VPWR VPWR _4276_/Y sky130_fd_sc_hd__nor2_1
X_3227_ _4519_/Q _3979_/B2 _3947_/B _3978_/A VGND VGND VPWR VPWR _4519_/D sky130_fd_sc_hd__a22o_1
XFILLER_67_561 VPWR VGND VPWR VGND sky130_ef_sc_hd__decap_12
X_3158_ _3159_/A _3159_/B _3159_/C VGND VGND VPWR VPWR _3179_/B sky130_fd_sc_hd__a21o_1
XFILLER_36_27 VGND VGND VPWR VPWR sky130_fd_sc_hd__fill_1
XFILLER_82_531 VGND VGND VPWR VPWR sky130_fd_sc_hd__fill_1
X_3089_ _4541_/Q _4550_/Q VGND VGND VPWR VPWR _3092_/B sky130_fd_sc_hd__or2_1
XFILLER_54_266 VGND VGND VPWR VPWR sky130_fd_sc_hd__fill_1
XFILLER_23_620 VGND VGND VPWR VPWR sky130_fd_sc_hd__decap_3
XFILLER_23_631 VGND VGND VPWR VPWR sky130_fd_sc_hd__decap_6
XFILLER_35_491 VGND VGND VPWR VPWR sky130_fd_sc_hd__fill_1
XFILLER_52_15 VPWR VGND VPWR VGND sky130_ef_sc_hd__decap_12
XFILLER_89_141 VGND VGND VPWR VPWR sky130_fd_sc_hd__decap_4
XFILLER_77_314 VGND VGND VPWR VPWR sky130_fd_sc_hd__fill_2
XFILLER_92_306 VGND VGND VPWR VPWR sky130_fd_sc_hd__fill_2
XFILLER_92_339 VGND VGND VPWR VPWR sky130_fd_sc_hd__fill_1
XFILLER_92_317 VGND VGND VPWR VPWR sky130_fd_sc_hd__decap_4
XFILLER_18_425 VGND VGND VPWR VPWR sky130_fd_sc_hd__fill_1
XFILLER_45_200 VGND VGND VPWR VPWR sky130_fd_sc_hd__fill_1
XFILLER_93_55 VGND VGND VPWR VPWR sky130_fd_sc_hd__fill_1
XFILLER_73_553 VGND VGND VPWR VPWR sky130_fd_sc_hd__decap_6
XTAP_TAPCELL_ROW_86_1178 VGND VPWR sky130_fd_sc_hd__tapvpwrvgnd_1
XFILLER_33_417 VGND VGND VPWR VPWR sky130_fd_sc_hd__decap_8
XFILLER_73_597 VPWR VGND VPWR VGND sky130_ef_sc_hd__decap_12
XFILLER_45_288 VGND VGND VPWR VPWR sky130_fd_sc_hd__fill_1
XFILLER_60_236 VGND VGND VPWR VPWR sky130_fd_sc_hd__decap_6
XFILLER_41_494 VGND VGND VPWR VPWR sky130_fd_sc_hd__decap_8
XTAP_TAPCELL_ROW_11_353 VGND VPWR sky130_fd_sc_hd__tapvpwrvgnd_1
XTAP_TAPCELL_ROW_97_1296 VGND VPWR sky130_fd_sc_hd__tapvpwrvgnd_1
X_2460_ _2482_/B1 _2461_/B _2459_/Y _2483_/B2 hold85/X VGND VGND VPWR VPWR _4449_/D
+ sky130_fd_sc_hd__a32o_1
XFILLER_96_601 VPWR VGND VPWR VGND sky130_ef_sc_hd__decap_12
X_2391_ _4406_/Q _2395_/A2 _2395_/B1 hold202/X VGND VGND VPWR VPWR _2391_/X sky130_fd_sc_hd__a22o_1
X_4130_ hold127/X _4139_/A1 _4130_/S VGND VGND VPWR VPWR _4660_/D sky130_fd_sc_hd__mux2_1
XFILLER_95_111 VGND VGND VPWR VPWR sky130_fd_sc_hd__fill_1
X_4061_ _4133_/A1 hold159/X _4067_/S VGND VGND VPWR VPWR _4598_/D sky130_fd_sc_hd__mux2_1
XFILLER_49_561 VGND VGND VPWR VPWR sky130_fd_sc_hd__decap_8
XFILLER_56_509 VGND VGND VPWR VPWR sky130_fd_sc_hd__fill_1
X_3012_ _3061_/A _3012_/B VGND VGND VPWR VPWR _3023_/A sky130_fd_sc_hd__xnor2_1
XFILLER_64_531 VGND VGND VPWR VPWR sky130_fd_sc_hd__fill_1
XFILLER_91_372 VGND VGND VPWR VPWR sky130_fd_sc_hd__decap_4
XTAP_TAPCELL_ROW_19_442 VGND VPWR sky130_fd_sc_hd__tapvpwrvgnd_1
XFILLER_36_266 VGND VGND VPWR VPWR sky130_fd_sc_hd__decap_3
XTAP_TAPCELL_ROW_47_751 VGND VPWR sky130_fd_sc_hd__tapvpwrvgnd_1
XFILLER_36_299 VGND VGND VPWR VPWR sky130_fd_sc_hd__fill_2
X_3914_ _3938_/B _3914_/B VGND VGND VPWR VPWR _3917_/A sky130_fd_sc_hd__and2b_1
X_3845_ _3845_/A _3847_/B VGND VGND VPWR VPWR _3845_/Y sky130_fd_sc_hd__nor2_1
XFILLER_22_29 VPWR VGND VPWR VGND sky130_ef_sc_hd__decap_12
X_3776_ _3776_/A _3776_/B _3776_/C VGND VGND VPWR VPWR _3778_/C sky130_fd_sc_hd__nand3_1
X_2727_ _2681_/Y _2726_/X _2724_/Y VGND VGND VPWR VPWR _2729_/B sky130_fd_sc_hd__a21oi_2
XFILLER_105_205 VPWR VGND VPWR VGND sky130_ef_sc_hd__decap_12
XFILLER_105_249 VPWR VGND VPWR VGND sky130_ef_sc_hd__decap_12
X_2658_ _3382_/A _2658_/B _2658_/C VGND VGND VPWR VPWR _2660_/B sky130_fd_sc_hd__nand3_2
XFILLER_99_461 VPWR VGND VPWR VGND sky130_ef_sc_hd__decap_12
X_2589_ _4491_/Q _3277_/B2 _3366_/A _4331_/B2 VGND VGND VPWR VPWR _4491_/D sky130_fd_sc_hd__a22o_1
Xfanout113 _4437_/Q VGND VGND VPWR VPWR _2249_/B sky130_fd_sc_hd__clkbuf_4
Xfanout102 _4736_/Q VGND VGND VPWR VPWR _4324_/S sky130_fd_sc_hd__buf_4
Xfanout146 fanout147/X VGND VGND VPWR VPWR fanout146/X sky130_fd_sc_hd__clkbuf_4
X_4328_ _2325_/C _3343_/A _4331_/A2 _4740_/Q VGND VGND VPWR VPWR _4740_/D sky130_fd_sc_hd__a2bb2o_1
Xfanout124 fanout126/X VGND VGND VPWR VPWR fanout124/X sky130_fd_sc_hd__clkbuf_4
Xfanout135 fanout145/X VGND VGND VPWR VPWR fanout135/X sky130_fd_sc_hd__buf_2
XFILLER_59_314 VPWR VGND VPWR VGND sky130_ef_sc_hd__decap_12
XFILLER_74_306 VGND VGND VPWR VPWR sky130_fd_sc_hd__fill_2
Xfanout168 fanout171/X VGND VGND VPWR VPWR fanout168/X sky130_fd_sc_hd__clkbuf_2
Xfanout157 fanout166/X VGND VGND VPWR VPWR fanout157/X sky130_fd_sc_hd__clkbuf_4
XFILLER_47_15 VPWR VGND VPWR VGND sky130_ef_sc_hd__decap_12
X_4259_ _4714_/Q _4259_/B VGND VGND VPWR VPWR _4259_/X sky130_fd_sc_hd__or2_1
XFILLER_74_317 VGND VGND VPWR VPWR sky130_fd_sc_hd__fill_2
XFILLER_82_350 VGND VGND VPWR VPWR sky130_fd_sc_hd__fill_1
XFILLER_70_501 VPWR VGND VPWR VGND sky130_ef_sc_hd__decap_12
XFILLER_27_277 VGND VGND VPWR VPWR sky130_fd_sc_hd__decap_3
XFILLER_82_383 VGND VGND VPWR VPWR sky130_fd_sc_hd__fill_1
XFILLER_70_545 VPWR VGND VPWR VGND sky130_ef_sc_hd__decap_12
XFILLER_55_597 VPWR VGND VPWR VGND sky130_ef_sc_hd__decap_12
XFILLER_63_69 VGND VGND VPWR VPWR sky130_fd_sc_hd__decap_6
XFILLER_42_247 VGND VGND VPWR VPWR sky130_fd_sc_hd__decap_4
XFILLER_70_589 VPWR VGND VPWR VGND sky130_ef_sc_hd__decap_12
XFILLER_10_177 VGND VGND VPWR VPWR sky130_fd_sc_hd__fill_1
XFILLER_88_77 VGND VGND VPWR VPWR sky130_fd_sc_hd__decap_6
XFILLER_78_601 VPWR VGND VPWR VGND sky130_ef_sc_hd__decap_12
XFILLER_93_615 VGND VGND VPWR VPWR sky130_fd_sc_hd__fill_1
XFILLER_18_200 VPWR VGND VPWR VGND sky130_ef_sc_hd__decap_12
XFILLER_80_309 VGND VGND VPWR VPWR sky130_fd_sc_hd__decap_4
XFILLER_33_203 VPWR VGND VPWR VGND sky130_ef_sc_hd__decap_12
XTAP_TAPCELL_ROW_16_412 VGND VPWR sky130_fd_sc_hd__tapvpwrvgnd_1
XTAP_TAPCELL_ROW_44_721 VGND VPWR sky130_fd_sc_hd__tapvpwrvgnd_1
XFILLER_14_483 VGND VGND VPWR VPWR sky130_fd_sc_hd__fill_1
XTAP_TAPCELL_ROW_99_1325 VGND VPWR sky130_fd_sc_hd__tapvpwrvgnd_1
X_3630_ _3532_/A _3532_/B _3628_/X _3629_/X VGND VGND VPWR VPWR _3637_/A sky130_fd_sc_hd__a211o_1
X_3561_ _3532_/A _3532_/B _3629_/A _3629_/B VGND VGND VPWR VPWR _3565_/B sky130_fd_sc_hd__a211o_1
X_2512_ _4465_/Q _2511_/B _2526_/A1 VGND VGND VPWR VPWR _2512_/Y sky130_fd_sc_hd__o21ai_1
XFILLER_52_3 VPWR VGND VPWR VGND sky130_ef_sc_hd__decap_12
X_3492_ _3491_/A _3491_/C _3491_/B VGND VGND VPWR VPWR _3492_/Y sky130_fd_sc_hd__o21ai_2
X_2443_ _2486_/A1 _2441_/Y _2442_/Y _2486_/B1 hold117/X VGND VGND VPWR VPWR _4444_/D
+ sky130_fd_sc_hd__a32o_1
X_2374_ hold36/X _2375_/A2 _2375_/B1 _4539_/Q VGND VGND VPWR VPWR _4389_/D sky130_fd_sc_hd__a22o_1
X_4113_ _4113_/A _4361_/Q _4113_/C _4140_/D VGND VGND VPWR VPWR _4121_/S sky130_fd_sc_hd__and4_4
XFILLER_96_475 VGND VGND VPWR VPWR sky130_fd_sc_hd__fill_1
X_4044_ _4134_/A1 hold160/X _4049_/S VGND VGND VPWR VPWR _4583_/D sky130_fd_sc_hd__mux2_1
XFILLER_37_542 VPWR VGND VPWR VGND sky130_ef_sc_hd__decap_12
XFILLER_12_409 VGND VGND VPWR VPWR sky130_fd_sc_hd__fill_1
XFILLER_33_39 VPWR VGND VPWR VGND sky130_ef_sc_hd__decap_12
X_3828_ _3828_/A _3828_/B VGND VGND VPWR VPWR _3828_/X sky130_fd_sc_hd__and2_1
XTAP_TAPCELL_ROW_50_779 VGND VPWR sky130_fd_sc_hd__tapvpwrvgnd_1
XFILLER_20_486 VGND VGND VPWR VPWR sky130_fd_sc_hd__fill_1
XFILLER_106_525 VGND VGND VPWR VPWR sky130_fd_sc_hd__decap_6
X_3759_ _3759_/A _3759_/B VGND VGND VPWR VPWR _3776_/C sky130_fd_sc_hd__nand2_1
XPHY_EDGE_ROW_18_Left_126 VGND VGND VPWR VPWR sky130_fd_sc_hd__decap_3
XFILLER_106_569 VPWR VGND VPWR VGND sky130_ef_sc_hd__decap_12
XTAP_TAPCELL_ROW_72_1019 VGND VPWR sky130_fd_sc_hd__tapvpwrvgnd_1
XFILLER_59_111 VGND VGND VPWR VPWR sky130_fd_sc_hd__fill_1
XFILLER_87_497 VGND VGND VPWR VPWR sky130_fd_sc_hd__decap_6
XFILLER_75_615 VGND VGND VPWR VPWR sky130_fd_sc_hd__fill_1
XTAP_TAPCELL_ROW_58_868 VGND VPWR sky130_fd_sc_hd__tapvpwrvgnd_1
XPHY_EDGE_ROW_27_Left_135 VGND VGND VPWR VPWR sky130_fd_sc_hd__decap_3
XFILLER_15_225 VPWR VGND VPWR VGND sky130_ef_sc_hd__decap_12
XFILLER_28_586 VGND VGND VPWR VPWR sky130_fd_sc_hd__fill_2
XTAP_TAPCELL_ROW_83_1148 VGND VPWR sky130_fd_sc_hd__tapvpwrvgnd_1
XFILLER_43_578 VGND VGND VPWR VPWR sky130_fd_sc_hd__fill_1
XPHY_EDGE_ROW_36_Left_144 VGND VGND VPWR VPWR sky130_fd_sc_hd__decap_3
XTAP_TAPCELL_ROW_94_1266 VGND VPWR sky130_fd_sc_hd__tapvpwrvgnd_1
XFILLER_97_217 VGND VGND VPWR VPWR sky130_fd_sc_hd__decap_6
XFILLER_78_431 VPWR VGND VPWR VGND sky130_ef_sc_hd__decap_12
XFILLER_78_475 VGND VGND VPWR VPWR sky130_fd_sc_hd__fill_1
XPHY_EDGE_ROW_45_Left_153 VGND VGND VPWR VPWR sky130_fd_sc_hd__decap_3
XFILLER_81_629 VGND VGND VPWR VPWR sky130_fd_sc_hd__decap_8
XFILLER_65_169 VGND VGND VPWR VPWR sky130_fd_sc_hd__decap_4
XFILLER_0_54 VGND VGND VPWR VPWR sky130_fd_sc_hd__fill_2
XFILLER_34_556 VPWR VGND VPWR VGND sky130_ef_sc_hd__decap_12
XTAP_TAPCELL_ROW_103_1362 VGND VPWR sky130_fd_sc_hd__tapvpwrvgnd_1
XFILLER_21_206 VGND VGND VPWR VPWR sky130_fd_sc_hd__fill_2
XFILLER_34_589 VGND VGND VPWR VPWR sky130_fd_sc_hd__decap_4
X_2992_ _4541_/Q _2992_/B _2992_/C VGND VGND VPWR VPWR _2994_/A sky130_fd_sc_hd__and3_1
X_4731_ _4734_/CLK _4731_/D fanout147/X VGND VGND VPWR VPWR _4731_/Q sky130_fd_sc_hd__dfrtp_2
X_4662_ clkload7/A _4662_/D fanout126/X VGND VGND VPWR VPWR _4662_/Q sky130_fd_sc_hd__dfrtp_1
XPHY_EDGE_ROW_54_Left_162 VGND VGND VPWR VPWR sky130_fd_sc_hd__decap_3
X_3613_ _3611_/Y _3612_/X _4537_/Q _3748_/B2 VGND VGND VPWR VPWR _4537_/D sky130_fd_sc_hd__a2bb2o_1
X_4593_ _4661_/CLK _4593_/D fanout123/X VGND VGND VPWR VPWR _4593_/Q sky130_fd_sc_hd__dfrtp_1
X_3544_ _4749_/Q _3544_/B VGND VGND VPWR VPWR _3546_/A sky130_fd_sc_hd__xor2_2
XFILLER_103_517 VPWR VGND VPWR VGND sky130_ef_sc_hd__decap_12
X_3475_ _3475_/A _3475_/B VGND VGND VPWR VPWR _3476_/B sky130_fd_sc_hd__or2_1
XFILLER_88_228 VGND VGND VPWR VPWR sky130_fd_sc_hd__decap_6
X_2426_ _2427_/B _2422_/Y _2425_/X VGND VGND VPWR VPWR _4437_/D sky130_fd_sc_hd__o21a_1
XPHY_EDGE_ROW_63_Left_171 VGND VGND VPWR VPWR sky130_fd_sc_hd__decap_3
X_2357_ hold124/X _2395_/A2 _2395_/B1 _4522_/Q VGND VGND VPWR VPWR _4372_/D sky130_fd_sc_hd__a22o_1
XFILLER_57_615 VGND VGND VPWR VPWR sky130_fd_sc_hd__fill_1
XFILLER_84_445 VPWR VGND VPWR VGND sky130_ef_sc_hd__decap_12
X_2288_ _2276_/X _2277_/X _2287_/X VGND VGND VPWR VPWR _2288_/X sky130_fd_sc_hd__o21a_1
XFILLER_84_489 VPWR VGND VPWR VGND sky130_ef_sc_hd__decap_12
X_4027_ _4095_/B _4094_/B _4137_/A1 _4016_/Y hold78/X VGND VGND VPWR VPWR _4570_/D
+ sky130_fd_sc_hd__a32o_1
XFILLER_44_309 VPWR VGND VPWR VGND sky130_ef_sc_hd__decap_12
XTAP_TAPCELL_ROW_27_529 VGND VPWR sky130_fd_sc_hd__tapvpwrvgnd_1
XTAP_TAPCELL_ROW_55_838 VGND VPWR sky130_fd_sc_hd__tapvpwrvgnd_1
XFILLER_64_191 VGND VGND VPWR VPWR sky130_fd_sc_hd__fill_1
XFILLER_25_567 VGND VGND VPWR VPWR sky130_fd_sc_hd__decap_4
XFILLER_44_27 VGND VGND VPWR VPWR sky130_fd_sc_hd__fill_1
XFILLER_52_353 VGND VGND VPWR VPWR sky130_fd_sc_hd__decap_3
XFILLER_12_206 VGND VGND VPWR VPWR sky130_fd_sc_hd__fill_1
XPHY_EDGE_ROW_72_Left_180 VGND VGND VPWR VPWR sky130_fd_sc_hd__decap_3
XFILLER_40_537 VGND VGND VPWR VPWR sky130_fd_sc_hd__fill_1
XFILLER_100_77 VGND VGND VPWR VPWR sky130_fd_sc_hd__decap_6
XFILLER_60_15 VPWR VGND VPWR VGND sky130_ef_sc_hd__decap_12
XFILLER_106_333 VPWR VGND VPWR VGND sky130_ef_sc_hd__decap_12
XFILLER_4_427 VGND VGND VPWR VPWR sky130_fd_sc_hd__fill_1
XFILLER_69_57 VPWR VGND VPWR VGND sky130_ef_sc_hd__decap_12
XFILLER_106_377 VPWR VGND VPWR VGND sky130_ef_sc_hd__decap_12
XFILLER_79_217 VGND VGND VPWR VPWR sky130_fd_sc_hd__fill_2
XFILLER_94_209 VGND VGND VPWR VPWR sky130_fd_sc_hd__decap_8
XFILLER_75_445 VGND VGND VPWR VPWR sky130_fd_sc_hd__decap_3
XFILLER_75_467 VPWR VGND VPWR VGND sky130_ef_sc_hd__decap_12
XFILLER_63_629 VGND VGND VPWR VPWR sky130_fd_sc_hd__decap_8
XFILLER_47_169 VGND VGND VPWR VPWR sky130_fd_sc_hd__fill_2
XFILLER_62_139 VGND VGND VPWR VPWR sky130_fd_sc_hd__fill_1
XFILLER_18_83 VGND VGND VPWR VPWR sky130_fd_sc_hd__fill_1
XFILLER_16_589 VGND VGND VPWR VPWR sky130_fd_sc_hd__decap_6
XFILLER_70_194 VGND VGND VPWR VPWR sky130_fd_sc_hd__fill_2
XFILLER_31_559 VGND VGND VPWR VPWR sky130_fd_sc_hd__fill_1
X_3260_ _3369_/A _3369_/B VGND VGND VPWR VPWR _3387_/B sky130_fd_sc_hd__nand2_1
X_3191_ _3191_/A _3191_/B VGND VGND VPWR VPWR _3987_/A sky130_fd_sc_hd__xnor2_4
X_2211_ _4705_/Q VGND VGND VPWR VPWR _4225_/A sky130_fd_sc_hd__inv_2
XFILLER_39_615 VGND VGND VPWR VPWR sky130_fd_sc_hd__fill_1
XFILLER_66_445 VGND VGND VPWR VPWR sky130_fd_sc_hd__fill_1
XFILLER_15_3 VPWR VGND VPWR VGND sky130_ef_sc_hd__decap_12
XFILLER_26_309 VGND VGND VPWR VPWR sky130_fd_sc_hd__decap_4
XFILLER_93_297 VPWR VGND VPWR VGND sky130_ef_sc_hd__decap_12
XFILLER_66_489 VPWR VGND VPWR VGND sky130_ef_sc_hd__decap_12
XFILLER_46_180 VPWR VGND VPWR VGND sky130_ef_sc_hd__decap_12
XTAP_TAPCELL_ROW_52_808 VGND VPWR sky130_fd_sc_hd__tapvpwrvgnd_1
XFILLER_61_161 VGND VGND VPWR VPWR sky130_fd_sc_hd__decap_6
X_4714_ _4715_/CLK _4714_/D fanout173/X VGND VGND VPWR VPWR _4714_/Q sky130_fd_sc_hd__dfrtp_1
X_2975_ _2975_/A _2975_/B VGND VGND VPWR VPWR _2977_/B sky130_fd_sc_hd__xnor2_1
XTAP_TAPCELL_ROW_60_896 VGND VPWR sky130_fd_sc_hd__tapvpwrvgnd_1
XTAP_TAPCELL_ROW_32_587 VGND VPWR sky130_fd_sc_hd__tapvpwrvgnd_1
X_4645_ _4679_/CLK _4645_/D fanout138/X VGND VGND VPWR VPWR _4645_/Q sky130_fd_sc_hd__dfrtp_1
XFILLER_30_29 VPWR VGND VPWR VGND sky130_ef_sc_hd__decap_12
X_4576_ _4671_/CLK _4576_/D fanout133/X VGND VGND VPWR VPWR _4576_/Q sky130_fd_sc_hd__dfrtp_1
X_3527_ _3556_/A _3483_/B _3497_/Y _3496_/Y VGND VGND VPWR VPWR _3527_/X sky130_fd_sc_hd__a31o_1
XFILLER_89_559 VGND VGND VPWR VPWR sky130_fd_sc_hd__fill_1
X_3458_ _3459_/A _3459_/B VGND VGND VPWR VPWR _3460_/A sky130_fd_sc_hd__or2_1
XFILLER_39_27 VPWR VGND VPWR VGND sky130_ef_sc_hd__decap_12
X_3389_ hold84/A _4563_/Q _4659_/Q _4595_/Q _3569_/S0 _3283_/S VGND VGND VPWR VPWR
+ _3391_/B sky130_fd_sc_hd__mux4_1
X_2409_ hold200/X _2420_/A2 _2420_/B1 _4510_/Q VGND VGND VPWR VPWR _2409_/X sky130_fd_sc_hd__a22o_1
XFILLER_84_253 VGND VGND VPWR VPWR sky130_fd_sc_hd__fill_1
XTAP_TAPCELL_ROW_4_279 VGND VPWR sky130_fd_sc_hd__tapvpwrvgnd_1
XFILLER_29_169 VGND VGND VPWR VPWR sky130_fd_sc_hd__decap_6
XFILLER_55_15 VPWR VGND VPWR VGND sky130_ef_sc_hd__decap_12
XTAP_TAPCELL_ROW_68_985 VGND VPWR sky130_fd_sc_hd__tapvpwrvgnd_1
XFILLER_45_629 VGND VGND VPWR VPWR sky130_fd_sc_hd__decap_8
XFILLER_44_139 VGND VGND VPWR VPWR sky130_fd_sc_hd__fill_1
XTAP_TAPCELL_ROW_80_1107 VGND VPWR sky130_fd_sc_hd__tapvpwrvgnd_1
XFILLER_13_515 VGND VGND VPWR VPWR sky130_fd_sc_hd__decap_3
XFILLER_9_508 VGND VGND VPWR VPWR sky130_fd_sc_hd__decap_4
XFILLER_71_69 VPWR VGND VPWR VGND sky130_ef_sc_hd__decap_12
XFILLER_40_389 VGND VGND VPWR VPWR sky130_fd_sc_hd__fill_1
XFILLER_106_141 VPWR VGND VPWR VGND sky130_ef_sc_hd__decap_12
XTAP_TAPCELL_ROW_91_1236 VGND VPWR sky130_fd_sc_hd__tapvpwrvgnd_1
XFILLER_96_77 VGND VGND VPWR VPWR sky130_fd_sc_hd__decap_6
XFILLER_95_529 VPWR VGND VPWR VGND sky130_ef_sc_hd__decap_12
XFILLER_48_401 VGND VGND VPWR VPWR sky130_fd_sc_hd__fill_1
XFILLER_88_581 VGND VGND VPWR VPWR sky130_fd_sc_hd__decap_6
XFILLER_75_220 VGND VGND VPWR VPWR sky130_fd_sc_hd__decap_4
XFILLER_0_474 VGND VGND VPWR VPWR sky130_fd_sc_hd__fill_2
XFILLER_75_253 VPWR VGND VPWR VGND sky130_ef_sc_hd__decap_12
Xhold71 hold71/A VGND VGND VPWR VPWR hold71/X sky130_fd_sc_hd__dlygate4sd3_1
Xhold60 hold60/A VGND VGND VPWR VPWR hold60/X sky130_fd_sc_hd__dlygate4sd3_1
Xhold82 hold82/A VGND VGND VPWR VPWR hold82/X sky130_fd_sc_hd__dlygate4sd3_1
Xhold93 hold93/A VGND VGND VPWR VPWR hold93/X sky130_fd_sc_hd__dlygate4sd3_1
XFILLER_16_342 VPWR VGND VPWR VGND sky130_ef_sc_hd__decap_12
XFILLER_71_481 VPWR VGND VPWR VGND sky130_ef_sc_hd__decap_12
XFILLER_31_323 VGND VGND VPWR VPWR sky130_fd_sc_hd__fill_1
XTAP_TAPCELL_ROW_100_1332 VGND VPWR sky130_fd_sc_hd__tapvpwrvgnd_1
XFILLER_31_367 VGND VGND VPWR VPWR sky130_fd_sc_hd__decap_6
X_2760_ _3348_/B _3348_/C VGND VGND VPWR VPWR _3541_/A sky130_fd_sc_hd__nand2_1
XFILLER_12_592 VGND VGND VPWR VPWR sky130_fd_sc_hd__decap_6
X_2691_ _2671_/X _2676_/B _2670_/Y VGND VGND VPWR VPWR _2703_/A sky130_fd_sc_hd__a21bo_1
X_4430_ _4513_/CLK _4430_/D fanout143/X VGND VGND VPWR VPWR _4430_/Q sky130_fd_sc_hd__dfrtp_1
XFILLER_8_585 VGND VGND VPWR VPWR sky130_fd_sc_hd__decap_3
XANTENNA_2 _4735_/Q VGND VGND VPWR VPWR sky130_fd_sc_hd__diode_2
XFILLER_6_53 VPWR VGND VPWR VGND sky130_ef_sc_hd__decap_12
XFILLER_98_301 VGND VGND VPWR VPWR sky130_fd_sc_hd__decap_6
X_4361_ _4671_/CLK _4361_/D fanout133/X VGND VGND VPWR VPWR _4361_/Q sky130_fd_sc_hd__dfrtp_1
XFILLER_98_345 VPWR VGND VPWR VGND sky130_ef_sc_hd__decap_12
X_3312_ _4524_/Q _3313_/B VGND VGND VPWR VPWR _3312_/X sky130_fd_sc_hd__and2_1
X_4292_ _4292_/A VGND VGND VPWR VPWR _4292_/Y sky130_fd_sc_hd__inv_2
XFILLER_98_389 VPWR VGND VPWR VGND sky130_ef_sc_hd__decap_12
X_3243_ _3243_/A _3243_/B VGND VGND VPWR VPWR _3967_/B sky130_fd_sc_hd__xnor2_2
XFILLER_58_209 VGND VGND VPWR VPWR sky130_fd_sc_hd__decap_3
XFILLER_39_412 VGND VGND VPWR VPWR sky130_fd_sc_hd__decap_6
X_3174_ _4584_/Q hold45/A _4648_/Q hold76/A _4324_/S _3174_/S1 VGND VGND VPWR VPWR
+ _3176_/B sky130_fd_sc_hd__mux4_1
XFILLER_39_445 VGND VGND VPWR VPWR sky130_fd_sc_hd__decap_3
XFILLER_66_297 VGND VGND VPWR VPWR sky130_fd_sc_hd__decap_8
XTAP_TAPCELL_ROW_1_238 VGND VPWR sky130_fd_sc_hd__tapvpwrvgnd_1
XFILLER_81_256 VGND VGND VPWR VPWR sky130_fd_sc_hd__fill_2
XFILLER_81_223 VGND VGND VPWR VPWR sky130_fd_sc_hd__fill_1
XTAP_TAPCELL_ROW_65_944 VGND VPWR sky130_fd_sc_hd__tapvpwrvgnd_1
XFILLER_26_139 VGND VGND VPWR VPWR sky130_fd_sc_hd__fill_1
XTAP_TAPCELL_ROW_37_635 VGND VPWR sky130_fd_sc_hd__tapvpwrvgnd_1
XFILLER_34_161 VGND VGND VPWR VPWR sky130_fd_sc_hd__fill_1
XFILLER_41_39 VPWR VGND VPWR VGND sky130_ef_sc_hd__decap_12
X_2958_ hold287/X _4345_/A2 _3751_/A _4345_/B2 VGND VGND VPWR VPWR _4507_/D sky130_fd_sc_hd__a22o_1
X_4628_ _4661_/CLK _4628_/D fanout123/X VGND VGND VPWR VPWR hold90/A sky130_fd_sc_hd__dfrtp_1
X_2889_ _4537_/Q _2889_/B _2889_/C VGND VGND VPWR VPWR _2891_/A sky130_fd_sc_hd__and3_1
XFILLER_104_601 VPWR VGND VPWR VGND sky130_ef_sc_hd__decap_12
XTAP_TAPCELL_ROW_77_1080 VGND VPWR sky130_fd_sc_hd__tapvpwrvgnd_1
XTAP_TAPCELL_ROW_9_327 VGND VPWR sky130_fd_sc_hd__tapvpwrvgnd_1
X_4559_ _4737_/CLK _4559_/D fanout122/X VGND VGND VPWR VPWR _4559_/Q sky130_fd_sc_hd__dfrtp_1
XFILLER_103_111 VGND VGND VPWR VPWR sky130_fd_sc_hd__fill_1
XFILLER_77_529 VPWR VGND VPWR VGND sky130_ef_sc_hd__decap_12
XFILLER_106_65 VPWR VGND VPWR VGND sky130_ef_sc_hd__decap_12
XFILLER_85_573 VPWR VGND VPWR VGND sky130_ef_sc_hd__decap_12
XFILLER_17_117 VGND VGND VPWR VPWR sky130_fd_sc_hd__fill_1
XFILLER_45_426 VGND VGND VPWR VPWR sky130_fd_sc_hd__decap_4
XFILLER_15_51 VGND VGND VPWR VPWR sky130_fd_sc_hd__decap_4
XFILLER_40_197 VPWR VGND VPWR VGND sky130_ef_sc_hd__decap_12
XFILLER_107_461 VPWR VGND VPWR VGND sky130_ef_sc_hd__decap_12
XFILLER_95_337 VPWR VGND VPWR VGND sky130_ef_sc_hd__decap_12
XFILLER_48_253 VGND VGND VPWR VPWR sky130_fd_sc_hd__decap_8
X_3930_ _4549_/Q _3908_/B _3886_/Y VGND VGND VPWR VPWR _3930_/Y sky130_fd_sc_hd__a21boi_1
XTAP_TAPCELL_ROW_62_914 VGND VPWR sky130_fd_sc_hd__tapvpwrvgnd_1
XTAP_TAPCELL_ROW_34_605 VGND VPWR sky130_fd_sc_hd__tapvpwrvgnd_1
XFILLER_16_161 VGND VGND VPWR VPWR sky130_fd_sc_hd__fill_1
X_3861_ _3859_/X _3861_/B VGND VGND VPWR VPWR _3863_/A sky130_fd_sc_hd__nand2b_1
XFILLER_82_3 VPWR VGND VPWR VGND sky130_ef_sc_hd__decap_12
X_3792_ _3769_/A _3769_/B _3767_/A _3766_/Y VGND VGND VPWR VPWR _3793_/B sky130_fd_sc_hd__o31ai_2
X_2812_ _2813_/B _2813_/C _2813_/A VGND VGND VPWR VPWR _2841_/B sky130_fd_sc_hd__a21o_1
XTAP_TAPCELL_ROW_14_384 VGND VPWR sky130_fd_sc_hd__tapvpwrvgnd_1
X_2743_ _2743_/A _2743_/B VGND VGND VPWR VPWR _2820_/B sky130_fd_sc_hd__or2_1
XTAP_TAPCELL_ROW_42_693 VGND VPWR sky130_fd_sc_hd__tapvpwrvgnd_1
XFILLER_8_393 VGND VGND VPWR VPWR sky130_fd_sc_hd__fill_1
X_2674_ _2674_/A VGND VGND VPWR VPWR _2674_/Y sky130_fd_sc_hd__inv_2
X_4413_ _4495_/CLK _4413_/D fanout147/X VGND VGND VPWR VPWR hold27/A sky130_fd_sc_hd__dfrtp_1
X_4344_ _4756_/Q _4345_/A2 _3727_/A _4345_/B2 VGND VGND VPWR VPWR _4756_/D sky130_fd_sc_hd__a22o_1
XFILLER_101_615 VGND VGND VPWR VPWR sky130_fd_sc_hd__fill_1
XFILLER_98_153 VPWR VGND VPWR VGND sky130_ef_sc_hd__decap_12
XFILLER_59_529 VPWR VGND VPWR VGND sky130_ef_sc_hd__decap_12
XFILLER_98_197 VPWR VGND VPWR VGND sky130_ef_sc_hd__decap_12
XFILLER_86_337 VPWR VGND VPWR VGND sky130_ef_sc_hd__decap_12
X_4275_ hold59/A hold30/A hold36/A _4397_/Q _2427_/A _2249_/B VGND VGND VPWR VPWR
+ _4276_/B sky130_fd_sc_hd__mux4_1
X_3226_ _3226_/A _3226_/B VGND VGND VPWR VPWR _3947_/B sky130_fd_sc_hd__xor2_2
XFILLER_86_359 VGND VGND VPWR VPWR sky130_fd_sc_hd__decap_4
X_3157_ _3179_/A _3157_/B VGND VGND VPWR VPWR _3159_/C sky130_fd_sc_hd__nand2_1
XFILLER_67_573 VPWR VGND VPWR VGND sky130_ef_sc_hd__decap_12
XFILLER_39_297 VGND VGND VPWR VPWR sky130_fd_sc_hd__fill_1
XFILLER_82_587 VGND VGND VPWR VPWR sky130_fd_sc_hd__fill_1
X_3088_ _3068_/B _3071_/B _3066_/X VGND VGND VPWR VPWR _3095_/A sky130_fd_sc_hd__a21o_1
XFILLER_14_109 VGND VGND VPWR VPWR sky130_fd_sc_hd__decap_6
XFILLER_22_131 VGND VGND VPWR VPWR sky130_fd_sc_hd__decap_8
XFILLER_52_27 VGND VGND VPWR VPWR sky130_fd_sc_hd__fill_1
XFILLER_22_197 VGND VGND VPWR VPWR sky130_fd_sc_hd__fill_1
XFILLER_104_475 VGND VGND VPWR VPWR sky130_fd_sc_hd__fill_1
XFILLER_77_57 VPWR VGND VPWR VGND sky130_ef_sc_hd__decap_12
XFILLER_18_404 VGND VGND VPWR VPWR sky130_fd_sc_hd__fill_1
XFILLER_45_223 VGND VGND VPWR VPWR sky130_fd_sc_hd__fill_1
XTAP_TAPCELL_ROW_86_1179 VGND VPWR sky130_fd_sc_hd__tapvpwrvgnd_1
XFILLER_26_83 VGND VGND VPWR VPWR sky130_fd_sc_hd__fill_1
XFILLER_60_215 VGND VGND VPWR VPWR sky130_fd_sc_hd__fill_1
XFILLER_13_131 VGND VGND VPWR VPWR sky130_fd_sc_hd__decap_3
XTAP_TAPCELL_ROW_11_354 VGND VPWR sky130_fd_sc_hd__tapvpwrvgnd_1
XFILLER_5_330 VGND VGND VPWR VPWR sky130_fd_sc_hd__decap_6
XTAP_TAPCELL_ROW_97_1297 VGND VPWR sky130_fd_sc_hd__tapvpwrvgnd_1
XFILLER_5_363 VGND VGND VPWR VPWR sky130_fd_sc_hd__decap_8
XFILLER_96_613 VPWR VGND VPWR VGND sky130_ef_sc_hd__decap_12
X_2390_ hold216/X _2395_/A2 _2395_/B1 _4491_/Q VGND VGND VPWR VPWR _2390_/X sky130_fd_sc_hd__a22o_1
X_4060_ _4132_/A1 hold166/X _4067_/S VGND VGND VPWR VPWR _4597_/D sky130_fd_sc_hd__mux2_1
XFILLER_95_167 VGND VGND VPWR VPWR sky130_fd_sc_hd__fill_1
XFILLER_83_329 VGND VGND VPWR VPWR sky130_fd_sc_hd__decap_6
X_3011_ _2911_/B _2963_/X _3009_/X _3010_/X VGND VGND VPWR VPWR _3012_/B sky130_fd_sc_hd__o31ai_2
XFILLER_64_587 VGND VGND VPWR VPWR sky130_fd_sc_hd__fill_1
XTAP_TAPCELL_ROW_19_443 VGND VPWR sky130_fd_sc_hd__tapvpwrvgnd_1
XTAP_TAPCELL_ROW_47_752 VGND VPWR sky130_fd_sc_hd__tapvpwrvgnd_1
XFILLER_24_429 VGND VGND VPWR VPWR sky130_fd_sc_hd__fill_2
XFILLER_51_215 VGND VGND VPWR VPWR sky130_fd_sc_hd__fill_1
XTAP_TAPCELL_ROW_106_1393 VGND VPWR sky130_fd_sc_hd__tapvpwrvgnd_1
X_3913_ _4764_/Q _3913_/B VGND VGND VPWR VPWR _3914_/B sky130_fd_sc_hd__nand2_1
X_3844_ _3843_/B _3843_/C _3843_/D _3843_/A VGND VGND VPWR VPWR _3847_/B sky130_fd_sc_hd__o31a_1
X_3775_ _3820_/A _3775_/B VGND VGND VPWR VPWR _3779_/A sky130_fd_sc_hd__nor2_1
X_2726_ _2639_/A _2639_/B _2661_/B _2725_/Y VGND VGND VPWR VPWR _2726_/X sky130_fd_sc_hd__o31a_1
XFILLER_105_217 VGND VGND VPWR VPWR sky130_fd_sc_hd__decap_6
X_2657_ _2660_/A VGND VGND VPWR VPWR _2657_/Y sky130_fd_sc_hd__inv_2
XTAP_TAPCELL_ROW_74_1050 VGND VPWR sky130_fd_sc_hd__tapvpwrvgnd_1
Xfanout103 _4736_/Q VGND VGND VPWR VPWR _3246_/S0 sky130_fd_sc_hd__clkbuf_4
X_2588_ _2588_/A _2588_/B VGND VGND VPWR VPWR _3366_/A sky130_fd_sc_hd__xnor2_2
XFILLER_99_473 VPWR VGND VPWR VGND sky130_ef_sc_hd__decap_12
XFILLER_86_101 VGND VGND VPWR VPWR sky130_fd_sc_hd__fill_1
Xfanout147 fanout155/X VGND VGND VPWR VPWR fanout147/X sky130_fd_sc_hd__buf_2
X_4327_ _4739_/Q _4331_/A2 _3322_/A _4331_/B2 VGND VGND VPWR VPWR _4739_/D sky130_fd_sc_hd__a22o_1
Xfanout125 fanout126/X VGND VGND VPWR VPWR fanout125/X sky130_fd_sc_hd__clkbuf_4
Xfanout114 _4319_/S0 VGND VGND VPWR VPWR _2427_/A sky130_fd_sc_hd__clkbuf_4
Xfanout136 fanout145/X VGND VGND VPWR VPWR fanout136/X sky130_fd_sc_hd__clkbuf_4
XFILLER_59_326 VGND VGND VPWR VPWR sky130_fd_sc_hd__decap_8
XFILLER_59_337 VGND VGND VPWR VPWR sky130_fd_sc_hd__decap_8
Xfanout158 fanout166/X VGND VGND VPWR VPWR fanout158/X sky130_fd_sc_hd__clkbuf_4
X_4258_ _4265_/C VGND VGND VPWR VPWR _4258_/Y sky130_fd_sc_hd__inv_2
XFILLER_47_27 VPWR VGND VPWR VGND sky130_ef_sc_hd__decap_12
Xfanout169 fanout171/X VGND VGND VPWR VPWR fanout169/X sky130_fd_sc_hd__clkbuf_4
X_3209_ _3209_/A _3209_/B VGND VGND VPWR VPWR _3922_/B sky130_fd_sc_hd__xnor2_2
XFILLER_67_370 VGND VGND VPWR VPWR sky130_fd_sc_hd__decap_8
X_4189_ _4194_/C _4188_/Y _4694_/Q _4217_/B1 VGND VGND VPWR VPWR _4694_/D sky130_fd_sc_hd__a2bb2o_1
XFILLER_103_55 VGND VGND VPWR VPWR sky130_fd_sc_hd__fill_1
XFILLER_63_15 VPWR VGND VPWR VGND sky130_ef_sc_hd__decap_12
XFILLER_70_513 VPWR VGND VPWR VGND sky130_ef_sc_hd__decap_12
XFILLER_70_557 VPWR VGND VPWR VGND sky130_ef_sc_hd__decap_12
XFILLER_23_473 VGND VGND VPWR VPWR sky130_fd_sc_hd__fill_1
XFILLER_7_617 VPWR VGND VPWR VGND sky130_ef_sc_hd__decap_12
XFILLER_12_41 VPWR VGND VPWR VGND sky130_ef_sc_hd__decap_12
XFILLER_12_85 VGND VGND VPWR VPWR sky130_fd_sc_hd__decap_6
XFILLER_2_355 VGND VGND VPWR VPWR sky130_fd_sc_hd__fill_1
XFILLER_78_613 VPWR VGND VPWR VGND sky130_ef_sc_hd__decap_12
Xhold190 _4577_/Q VGND VGND VPWR VPWR hold190/X sky130_fd_sc_hd__dlygate4sd3_1
XFILLER_77_134 VGND VGND VPWR VPWR sky130_fd_sc_hd__decap_6
XFILLER_65_318 VGND VGND VPWR VPWR sky130_fd_sc_hd__decap_3
XFILLER_18_212 VPWR VGND VPWR VGND sky130_ef_sc_hd__decap_12
XPHY_EDGE_ROW_16_Right_16 VGND VGND VPWR VPWR sky130_fd_sc_hd__decap_3
XTAP_TAPCELL_ROW_16_413 VGND VPWR sky130_fd_sc_hd__tapvpwrvgnd_1
XFILLER_33_215 VGND VGND VPWR VPWR sky130_fd_sc_hd__decap_8
XTAP_TAPCELL_ROW_44_711 VGND VPWR sky130_fd_sc_hd__tapvpwrvgnd_1
XFILLER_46_587 VGND VGND VPWR VPWR sky130_fd_sc_hd__fill_1
XTAP_TAPCELL_ROW_99_1326 VGND VPWR sky130_fd_sc_hd__tapvpwrvgnd_1
XPHY_EDGE_ROW_25_Right_25 VGND VGND VPWR VPWR sky130_fd_sc_hd__decap_3
X_3560_ _3628_/A _3628_/B VGND VGND VPWR VPWR _3565_/A sky130_fd_sc_hd__or2_1
X_2511_ _4465_/Q _2511_/B VGND VGND VPWR VPWR _2518_/C sky130_fd_sc_hd__and2_1
X_3491_ _3491_/A _3491_/B _3491_/C VGND VGND VPWR VPWR _3491_/X sky130_fd_sc_hd__or3_1
XFILLER_102_209 VPWR VGND VPWR VGND sky130_ef_sc_hd__decap_12
X_2442_ _2442_/A _2442_/B VGND VGND VPWR VPWR _2442_/Y sky130_fd_sc_hd__nand2_1
XFILLER_45_3 VPWR VGND VPWR VGND sky130_ef_sc_hd__decap_12
XFILLER_96_421 VPWR VGND VPWR VGND sky130_ef_sc_hd__decap_12
X_2373_ hold17/X _4238_/B1 _2408_/B1 _4538_/Q VGND VGND VPWR VPWR _4388_/D sky130_fd_sc_hd__a22o_1
X_4112_ hold140/X _4030_/X _4112_/S VGND VGND VPWR VPWR _4644_/D sky130_fd_sc_hd__mux2_1
XFILLER_83_104 VGND VGND VPWR VPWR sky130_fd_sc_hd__decap_8
X_4043_ _4133_/A1 hold98/X _4049_/S VGND VGND VPWR VPWR _4582_/D sky130_fd_sc_hd__mux2_1
XPHY_EDGE_ROW_34_Right_34 VGND VGND VPWR VPWR sky130_fd_sc_hd__decap_3
XFILLER_37_554 VGND VGND VPWR VPWR sky130_fd_sc_hd__decap_6
XFILLER_91_181 VGND VGND VPWR VPWR sky130_fd_sc_hd__decap_6
XFILLER_32_281 VGND VGND VPWR VPWR sky130_fd_sc_hd__decap_6
X_3827_ _3902_/A _3799_/B _3783_/A VGND VGND VPWR VPWR _3828_/B sky130_fd_sc_hd__a21o_1
XPHY_EDGE_ROW_43_Right_43 VGND VGND VPWR VPWR sky130_fd_sc_hd__decap_3
X_3758_ _3759_/A _3759_/B VGND VGND VPWR VPWR _3778_/A sky130_fd_sc_hd__or2_1
X_2709_ _2707_/A _2706_/B _2704_/X VGND VGND VPWR VPWR _2734_/A sky130_fd_sc_hd__a21o_2
X_3689_ _3644_/C _3689_/B VGND VGND VPWR VPWR _3689_/Y sky130_fd_sc_hd__nand2b_1
XFILLER_99_281 VPWR VGND VPWR VGND sky130_ef_sc_hd__decap_12
XFILLER_87_410 VPWR VGND VPWR VGND sky130_ef_sc_hd__decap_12
XFILLER_58_15 VPWR VGND VPWR VGND sky130_ef_sc_hd__decap_12
XFILLER_59_101 VGND VGND VPWR VPWR sky130_fd_sc_hd__fill_1
XFILLER_47_307 VGND VGND VPWR VPWR sky130_fd_sc_hd__decap_6
XPHY_EDGE_ROW_52_Right_52 VGND VGND VPWR VPWR sky130_fd_sc_hd__decap_3
XFILLER_43_502 VGND VGND VPWR VPWR sky130_fd_sc_hd__fill_2
XTAP_TAPCELL_ROW_58_869 VGND VPWR sky130_fd_sc_hd__tapvpwrvgnd_1
XTAP_TAPCELL_ROW_83_1149 VGND VPWR sky130_fd_sc_hd__tapvpwrvgnd_1
XFILLER_82_192 VGND VGND VPWR VPWR sky130_fd_sc_hd__decap_4
XFILLER_70_332 VGND VGND VPWR VPWR sky130_fd_sc_hd__decap_4
XFILLER_15_237 VGND VGND VPWR VPWR sky130_fd_sc_hd__decap_8
XFILLER_70_387 VGND VGND VPWR VPWR sky130_fd_sc_hd__decap_6
XFILLER_70_365 VGND VGND VPWR VPWR sky130_fd_sc_hd__fill_2
XPHY_EDGE_ROW_61_Right_61 VGND VGND VPWR VPWR sky130_fd_sc_hd__decap_3
XFILLER_11_465 VGND VGND VPWR VPWR sky130_fd_sc_hd__decap_6
XFILLER_7_414 VGND VGND VPWR VPWR sky130_fd_sc_hd__decap_4
XFILLER_23_51 VGND VGND VPWR VPWR sky130_fd_sc_hd__decap_4
XFILLER_7_447 VGND VGND VPWR VPWR sky130_fd_sc_hd__fill_1
XTAP_TAPCELL_ROW_21_460 VGND VPWR sky130_fd_sc_hd__tapvpwrvgnd_1
XFILLER_99_55 VGND VGND VPWR VPWR sky130_fd_sc_hd__fill_1
XTAP_TAPCELL_ROW_94_1267 VGND VPWR sky130_fd_sc_hd__tapvpwrvgnd_1
XFILLER_78_421 VGND VGND VPWR VPWR sky130_fd_sc_hd__fill_2
XPHY_EDGE_ROW_70_Right_70 VGND VGND VPWR VPWR sky130_fd_sc_hd__decap_3
XFILLER_2_141 VGND VGND VPWR VPWR sky130_fd_sc_hd__decap_8
XFILLER_78_443 VPWR VGND VPWR VGND sky130_ef_sc_hd__decap_12
XFILLER_38_307 VGND VGND VPWR VPWR sky130_fd_sc_hd__fill_1
XFILLER_19_554 VGND VGND VPWR VPWR sky130_fd_sc_hd__decap_6
XFILLER_80_107 VGND VGND VPWR VPWR sky130_fd_sc_hd__fill_2
XFILLER_34_568 VGND VGND VPWR VPWR sky130_fd_sc_hd__decap_3
X_2991_ _4537_/Q _3836_/A VGND VGND VPWR VPWR _2992_/C sky130_fd_sc_hd__nand2_1
XTAP_TAPCELL_ROW_103_1363 VGND VPWR sky130_fd_sc_hd__tapvpwrvgnd_1
XFILLER_61_398 VGND VGND VPWR VPWR sky130_fd_sc_hd__decap_8
X_4730_ _4735_/CLK _4730_/D fanout148/X VGND VGND VPWR VPWR _4730_/Q sky130_fd_sc_hd__dfrtp_2
X_4661_ _4661_/CLK _4661_/D fanout121/X VGND VGND VPWR VPWR _4661_/Q sky130_fd_sc_hd__dfrtp_1
X_3612_ _3583_/A _3588_/X _3610_/Y _2325_/C VGND VGND VPWR VPWR _3612_/X sky130_fd_sc_hd__a31o_1
X_4592_ _4656_/CLK _4592_/D fanout120/X VGND VGND VPWR VPWR _4592_/Q sky130_fd_sc_hd__dfrtp_1
X_3543_ _4747_/Q _4748_/Q _4749_/Q _3543_/D VGND VGND VPWR VPWR _3567_/B sky130_fd_sc_hd__or4_1
X_3474_ _3475_/A _3475_/B VGND VGND VPWR VPWR _3476_/A sky130_fd_sc_hd__nand2_1
XFILLER_103_529 VPWR VGND VPWR VGND sky130_ef_sc_hd__decap_12
X_2425_ _2248_/Y _2423_/B _2422_/B VGND VGND VPWR VPWR _2425_/X sky130_fd_sc_hd__a21o_1
XFILLER_69_432 VGND VGND VPWR VPWR sky130_fd_sc_hd__fill_1
XFILLER_96_251 VGND VGND VPWR VPWR sky130_fd_sc_hd__fill_1
XFILLER_84_413 VGND VGND VPWR VPWR sky130_fd_sc_hd__fill_1
XFILLER_28_29 VPWR VGND VPWR VGND sky130_ef_sc_hd__decap_12
X_2356_ _2356_/A _4770_/Q _2356_/C VGND VGND VPWR VPWR _2356_/X sky130_fd_sc_hd__and3_1
X_2287_ _2279_/X _2286_/X _2278_/X VGND VGND VPWR VPWR _2287_/X sky130_fd_sc_hd__a21o_1
XFILLER_84_457 VPWR VGND VPWR VGND sky130_ef_sc_hd__decap_12
X_4026_ _4733_/Q _4030_/B VGND VGND VPWR VPWR _4026_/X sky130_fd_sc_hd__and2_2
XFILLER_37_351 VGND VGND VPWR VPWR sky130_fd_sc_hd__decap_3
XTAP_TAPCELL_ROW_55_839 VGND VPWR sky130_fd_sc_hd__tapvpwrvgnd_1
XFILLER_52_365 VPWR VGND VPWR VGND sky130_ef_sc_hd__decap_12
XFILLER_60_27 VGND VGND VPWR VPWR sky130_fd_sc_hd__fill_1
XFILLER_20_295 VPWR VGND VPWR VGND sky130_ef_sc_hd__decap_12
Xclkbuf_3_0__f_clk clkbuf_0_clk/X VGND VGND VPWR VPWR clkload0/A sky130_fd_sc_hd__clkbuf_16
XFILLER_106_301 VGND VGND VPWR VPWR sky130_fd_sc_hd__decap_6
XFILLER_106_345 VPWR VGND VPWR VGND sky130_ef_sc_hd__decap_12
XFILLER_106_389 VPWR VGND VPWR VGND sky130_ef_sc_hd__decap_12
XFILLER_69_69 VPWR VGND VPWR VGND sky130_ef_sc_hd__decap_12
XFILLER_0_601 VGND VGND VPWR VPWR sky130_fd_sc_hd__decap_8
XFILLER_75_413 VGND VGND VPWR VPWR sky130_fd_sc_hd__decap_8
XFILLER_47_104 VGND VGND VPWR VPWR sky130_fd_sc_hd__decap_8
XFILLER_87_295 VGND VGND VPWR VPWR sky130_fd_sc_hd__decap_6
XFILLER_85_57 VPWR VGND VPWR VGND sky130_ef_sc_hd__decap_12
XFILLER_75_479 VPWR VGND VPWR VGND sky130_ef_sc_hd__decap_12
XFILLER_62_118 VPWR VGND VPWR VGND sky130_ef_sc_hd__decap_12
XFILLER_43_332 VGND VGND VPWR VPWR sky130_fd_sc_hd__decap_4
XFILLER_55_192 VGND VGND VPWR VPWR sky130_fd_sc_hd__decap_6
XFILLER_31_505 VGND VGND VPWR VPWR sky130_fd_sc_hd__fill_1
XFILLER_34_61 VGND VGND VPWR VPWR sky130_fd_sc_hd__decap_3
XFILLER_34_94 VGND VGND VPWR VPWR sky130_fd_sc_hd__decap_3
XFILLER_7_277 VGND VGND VPWR VPWR sky130_fd_sc_hd__decap_3
XFILLER_50_93 VGND VGND VPWR VPWR sky130_fd_sc_hd__fill_1
XPHY_EDGE_ROW_0_Left_108 VGND VGND VPWR VPWR sky130_fd_sc_hd__decap_3
X_2210_ _4462_/Q VGND VGND VPWR VPWR _2210_/Y sky130_fd_sc_hd__inv_2
XFILLER_78_262 VGND VGND VPWR VPWR sky130_fd_sc_hd__fill_2
X_3190_ _3171_/A _3171_/B _3167_/X VGND VGND VPWR VPWR _3191_/B sky130_fd_sc_hd__a21o_2
XFILLER_81_449 VPWR VGND VPWR VGND sky130_ef_sc_hd__decap_12
XFILLER_46_192 VGND VGND VPWR VPWR sky130_fd_sc_hd__decap_4
XTAP_TAPCELL_ROW_52_809 VGND VPWR sky130_fd_sc_hd__tapvpwrvgnd_1
XFILLER_61_140 VGND VGND VPWR VPWR sky130_fd_sc_hd__fill_1
XFILLER_34_365 VPWR VGND VPWR VGND sky130_ef_sc_hd__decap_12
XFILLER_61_184 VGND VGND VPWR VPWR sky130_fd_sc_hd__fill_1
XFILLER_34_398 VPWR VGND VPWR VGND sky130_ef_sc_hd__decap_12
X_2974_ _3013_/A _2974_/B VGND VGND VPWR VPWR _2975_/B sky130_fd_sc_hd__xnor2_1
X_4713_ _4716_/CLK _4713_/D fanout165/X VGND VGND VPWR VPWR _4713_/Q sky130_fd_sc_hd__dfrtp_2
XTAP_TAPCELL_ROW_60_897 VGND VPWR sky130_fd_sc_hd__tapvpwrvgnd_1
XTAP_TAPCELL_ROW_32_588 VGND VPWR sky130_fd_sc_hd__tapvpwrvgnd_1
XFILLER_107_109 VGND VGND VPWR VPWR sky130_fd_sc_hd__decap_3
X_4644_ _4756_/CLK _4644_/D fanout134/X VGND VGND VPWR VPWR _4644_/Q sky130_fd_sc_hd__dfrtp_1
X_4575_ _4756_/CLK _4575_/D fanout136/X VGND VGND VPWR VPWR _4575_/Q sky130_fd_sc_hd__dfrtp_1
XFILLER_89_505 VPWR VGND VPWR VGND sky130_ef_sc_hd__decap_12
X_3526_ _3526_/A _3526_/B _3526_/C _3442_/A VGND VGND VPWR VPWR _3532_/A sky130_fd_sc_hd__or4b_2
XFILLER_103_337 VPWR VGND VPWR VGND sky130_ef_sc_hd__decap_12
X_3457_ hold43/A hold92/A _4662_/Q _4598_/Q _3599_/S0 _3519_/S VGND VGND VPWR VPWR
+ _3459_/B sky130_fd_sc_hd__mux4_1
XFILLER_39_39 VPWR VGND VPWR VGND sky130_ef_sc_hd__decap_12
XFILLER_69_262 VGND VGND VPWR VPWR sky130_fd_sc_hd__fill_2
X_3388_ _3409_/B _3388_/B VGND VGND VPWR VPWR _3391_/A sky130_fd_sc_hd__nor2_1
X_2408_ hold56/X _2408_/A2 _2408_/B1 _4509_/Q VGND VGND VPWR VPWR hold57/A sky130_fd_sc_hd__a22o_1
XFILLER_69_284 VGND VGND VPWR VPWR sky130_fd_sc_hd__decap_8
XFILLER_69_273 VGND VGND VPWR VPWR sky130_fd_sc_hd__fill_1
X_2339_ _4095_/A VGND VGND VPWR VPWR _4556_/D sky130_fd_sc_hd__inv_2
XTAP_TAPCELL_ROW_68_975 VGND VPWR sky130_fd_sc_hd__tapvpwrvgnd_1
XPHY_EDGE_ROW_2_Right_2 VGND VGND VPWR VPWR sky130_fd_sc_hd__decap_3
XFILLER_29_148 VGND VGND VPWR VPWR sky130_fd_sc_hd__fill_2
XFILLER_57_446 VGND VGND VPWR VPWR sky130_fd_sc_hd__fill_2
XFILLER_84_265 VGND VGND VPWR VPWR sky130_fd_sc_hd__decap_6
X_4009_ _4131_/D _4140_/B _4131_/B _4363_/Q VGND VGND VPWR VPWR _4085_/B sky130_fd_sc_hd__or4b_2
XFILLER_55_27 VPWR VGND VPWR VGND sky130_ef_sc_hd__decap_12
XTAP_TAPCELL_ROW_80_1108 VGND VPWR sky130_fd_sc_hd__tapvpwrvgnd_1
XFILLER_71_15 VPWR VGND VPWR VGND sky130_ef_sc_hd__decap_12
XFILLER_52_195 VGND VGND VPWR VPWR sky130_fd_sc_hd__fill_1
XFILLER_20_41 VPWR VGND VPWR VGND sky130_ef_sc_hd__decap_12
XFILLER_106_153 VPWR VGND VPWR VGND sky130_ef_sc_hd__decap_12
XTAP_TAPCELL_ROW_91_1237 VGND VPWR sky130_fd_sc_hd__tapvpwrvgnd_1
XFILLER_20_85 VGND VGND VPWR VPWR sky130_fd_sc_hd__decap_6
XFILLER_106_197 VPWR VGND VPWR VGND sky130_ef_sc_hd__decap_12
XFILLER_0_453 VGND VGND VPWR VPWR sky130_fd_sc_hd__fill_1
Xhold50 hold50/A VGND VGND VPWR VPWR hold50/X sky130_fd_sc_hd__dlygate4sd3_1
XFILLER_48_413 VGND VGND VPWR VPWR sky130_fd_sc_hd__decap_6
Xhold83 hold83/A VGND VGND VPWR VPWR hold83/X sky130_fd_sc_hd__dlygate4sd3_1
Xhold72 hold72/A VGND VGND VPWR VPWR hold72/X sky130_fd_sc_hd__dlygate4sd3_1
Xhold61 hold61/A VGND VGND VPWR VPWR hold61/X sky130_fd_sc_hd__dlygate4sd3_1
XFILLER_75_287 VPWR VGND VPWR VGND sky130_ef_sc_hd__decap_12
XFILLER_75_265 VGND VGND VPWR VPWR sky130_fd_sc_hd__decap_3
Xhold94 hold94/A VGND VGND VPWR VPWR hold94/X sky130_fd_sc_hd__dlygate4sd3_1
XFILLER_63_449 VGND VGND VPWR VPWR sky130_fd_sc_hd__decap_6
Xclkbuf_leaf_55_clk clkload0/A VGND VGND VPWR VPWR _4740_/CLK sky130_fd_sc_hd__clkbuf_8
XFILLER_16_354 VGND VGND VPWR VPWR sky130_fd_sc_hd__decap_8
XFILLER_16_365 VGND VGND VPWR VPWR sky130_fd_sc_hd__decap_4
XFILLER_71_493 VGND VGND VPWR VPWR sky130_fd_sc_hd__decap_8
XFILLER_16_387 VPWR VGND VPWR VGND sky130_ef_sc_hd__decap_12
XFILLER_31_335 VGND VGND VPWR VPWR sky130_fd_sc_hd__fill_1
XTAP_TAPCELL_ROW_100_1333 VGND VPWR sky130_fd_sc_hd__tapvpwrvgnd_1
X_2690_ _2688_/A _2688_/B _2685_/X VGND VGND VPWR VPWR _2707_/A sky130_fd_sc_hd__a21o_1
XANTENNA_3 fanout173/X VGND VGND VPWR VPWR sky130_fd_sc_hd__diode_2
XPHY_EDGE_ROW_91_Left_199 VGND VGND VPWR VPWR sky130_fd_sc_hd__decap_3
XFILLER_6_65 VPWR VGND VPWR VGND sky130_ef_sc_hd__decap_12
X_4360_ _4671_/CLK _4360_/D fanout133/X VGND VGND VPWR VPWR _4360_/Q sky130_fd_sc_hd__dfrtp_1
X_3311_ _3311_/A _3311_/B VGND VGND VPWR VPWR _3313_/B sky130_fd_sc_hd__xor2_1
XFILLER_98_357 VGND VGND VPWR VPWR sky130_fd_sc_hd__decap_6
X_4291_ _4407_/Q hold21/A hold56/A _4431_/Q _4319_/S0 _2249_/B VGND VGND VPWR VPWR
+ _4292_/A sky130_fd_sc_hd__mux4_1
XFILLER_100_307 VGND VGND VPWR VPWR sky130_fd_sc_hd__fill_1
X_3242_ _4520_/Q _3242_/B VGND VGND VPWR VPWR _3243_/B sky130_fd_sc_hd__xnor2_2
X_3173_ hold303/X _4355_/A2 _3882_/A _4354_/B2 VGND VGND VPWR VPWR _4516_/D sky130_fd_sc_hd__a22o_1
XFILLER_39_457 VPWR VGND VPWR VGND sky130_ef_sc_hd__decap_12
XFILLER_66_287 VGND VGND VPWR VPWR sky130_fd_sc_hd__decap_4
XTAP_TAPCELL_ROW_1_239 VGND VPWR sky130_fd_sc_hd__tapvpwrvgnd_1
XTAP_TAPCELL_ROW_65_945 VGND VPWR sky130_fd_sc_hd__tapvpwrvgnd_1
Xclkbuf_leaf_46_clk clkload4/A VGND VGND VPWR VPWR _4532_/CLK sky130_fd_sc_hd__clkbuf_8
XTAP_TAPCELL_ROW_37_636 VGND VPWR sky130_fd_sc_hd__tapvpwrvgnd_1
XFILLER_47_490 VPWR VGND VPWR VGND sky130_ef_sc_hd__decap_12
XFILLER_22_313 VGND VGND VPWR VPWR sky130_fd_sc_hd__fill_1
X_2957_ _3650_/A VGND VGND VPWR VPWR _3751_/A sky130_fd_sc_hd__inv_2
X_2888_ _4533_/Q _4542_/Q VGND VGND VPWR VPWR _2889_/C sky130_fd_sc_hd__nand2_1
X_4627_ _4661_/CLK _4627_/D fanout121/X VGND VGND VPWR VPWR hold84/A sky130_fd_sc_hd__dfrtp_1
XFILLER_104_613 VPWR VGND VPWR VGND sky130_ef_sc_hd__decap_12
XTAP_TAPCELL_ROW_77_1081 VGND VPWR sky130_fd_sc_hd__tapvpwrvgnd_1
XTAP_TAPCELL_ROW_9_328 VGND VPWR sky130_fd_sc_hd__tapvpwrvgnd_1
X_4558_ _4737_/CLK _4558_/D fanout122/X VGND VGND VPWR VPWR _4558_/Q sky130_fd_sc_hd__dfrtp_1
X_4489_ _4532_/CLK _4489_/D fanout153/X VGND VGND VPWR VPWR _4489_/Q sky130_fd_sc_hd__dfrtp_1
X_3509_ _4533_/Q _3510_/B VGND VGND VPWR VPWR _3509_/Y sky130_fd_sc_hd__nor2_1
XFILLER_103_167 VGND VGND VPWR VPWR sky130_fd_sc_hd__fill_1
XFILLER_89_357 VGND VGND VPWR VPWR sky130_fd_sc_hd__decap_4
XFILLER_106_77 VGND VGND VPWR VPWR sky130_fd_sc_hd__decap_6
XFILLER_66_15 VPWR VGND VPWR VGND sky130_ef_sc_hd__decap_12
XFILLER_85_541 VPWR VGND VPWR VGND sky130_ef_sc_hd__decap_12
XFILLER_57_232 VPWR VGND VPWR VGND sky130_ef_sc_hd__decap_12
XFILLER_85_585 VPWR VGND VPWR VGND sky130_ef_sc_hd__decap_12
Xclkbuf_leaf_37_clk _4459_/CLK VGND VGND VPWR VPWR _4706_/CLK sky130_fd_sc_hd__clkbuf_8
XFILLER_45_449 VGND VGND VPWR VPWR sky130_fd_sc_hd__decap_3
XFILLER_25_140 VGND VGND VPWR VPWR sky130_fd_sc_hd__decap_4
XFILLER_13_324 VPWR VGND VPWR VGND sky130_ef_sc_hd__decap_12
XFILLER_40_165 VPWR VGND VPWR VGND sky130_ef_sc_hd__decap_12
XFILLER_31_51 VGND VGND VPWR VPWR sky130_fd_sc_hd__decap_4
XFILLER_107_473 VGND VGND VPWR VPWR sky130_fd_sc_hd__decap_3
XFILLER_95_305 VPWR VGND VPWR VGND sky130_ef_sc_hd__decap_12
XFILLER_95_349 VPWR VGND VPWR VGND sky130_ef_sc_hd__decap_12
XFILLER_36_449 VGND VGND VPWR VPWR sky130_fd_sc_hd__fill_1
Xclkbuf_leaf_28_clk clkload6/A VGND VGND VPWR VPWR _4715_/CLK sky130_fd_sc_hd__clkbuf_8
XTAP_TAPCELL_ROW_62_915 VGND VPWR sky130_fd_sc_hd__tapvpwrvgnd_1
XTAP_TAPCELL_ROW_34_606 VGND VPWR sky130_fd_sc_hd__tapvpwrvgnd_1
XFILLER_51_408 VGND VGND VPWR VPWR sky130_fd_sc_hd__fill_1
X_3860_ _3860_/A _3860_/B VGND VGND VPWR VPWR _3861_/B sky130_fd_sc_hd__or2_1
XFILLER_71_290 VPWR VGND VPWR VGND sky130_ef_sc_hd__decap_12
X_3791_ _3791_/A _3791_/B VGND VGND VPWR VPWR _3838_/A sky130_fd_sc_hd__xor2_1
X_2811_ _2765_/Y _2808_/C _2810_/Y _2791_/B VGND VGND VPWR VPWR _2813_/C sky130_fd_sc_hd__o211a_1
XFILLER_75_3 VPWR VGND VPWR VGND sky130_ef_sc_hd__decap_12
XTAP_TAPCELL_ROW_14_385 VGND VPWR sky130_fd_sc_hd__tapvpwrvgnd_1
X_2742_ _2741_/B _2741_/C _4531_/Q VGND VGND VPWR VPWR _2743_/B sky130_fd_sc_hd__a21oi_1
XTAP_TAPCELL_ROW_42_694 VGND VPWR sky130_fd_sc_hd__tapvpwrvgnd_1
X_2673_ _2673_/A _2673_/B VGND VGND VPWR VPWR _2674_/A sky130_fd_sc_hd__nor2_1
X_4412_ _4501_/CLK hold19/X fanout130/X VGND VGND VPWR VPWR hold18/A sky130_fd_sc_hd__dfrtp_1
XPHY_EDGE_ROW_99_Right_99 VGND VGND VPWR VPWR sky130_fd_sc_hd__decap_3
XFILLER_98_121 VPWR VGND VPWR VGND sky130_ef_sc_hd__decap_12
X_4343_ _4755_/Q _4345_/A2 _3706_/A _4345_/B2 VGND VGND VPWR VPWR _4755_/D sky130_fd_sc_hd__a22o_1
XFILLER_98_165 VPWR VGND VPWR VGND sky130_ef_sc_hd__decap_12
X_4274_ uo_out[0] _4273_/Y _4323_/S VGND VGND VPWR VPWR _4719_/D sky130_fd_sc_hd__mux2_1
X_3225_ _3206_/X _3209_/B _3205_/X VGND VGND VPWR VPWR _3226_/B sky130_fd_sc_hd__a21o_1
XFILLER_86_349 VGND VGND VPWR VPWR sky130_fd_sc_hd__decap_4
XFILLER_67_541 VPWR VGND VPWR VGND sky130_ef_sc_hd__decap_12
XFILLER_39_232 VPWR VGND VPWR VGND sky130_ef_sc_hd__decap_12
X_3156_ _4762_/Q _3156_/B VGND VGND VPWR VPWR _3157_/B sky130_fd_sc_hd__or2_1
XFILLER_67_585 VPWR VGND VPWR VGND sky130_ef_sc_hd__decap_12
XFILLER_82_533 VPWR VGND VPWR VGND sky130_ef_sc_hd__decap_12
Xclkbuf_leaf_19_clk clkload3/A VGND VGND VPWR VPWR _4517_/CLK sky130_fd_sc_hd__clkbuf_8
X_3087_ _3087_/A _3087_/B VGND VGND VPWR VPWR _3096_/A sky130_fd_sc_hd__xor2_2
XFILLER_36_29 VPWR VGND VPWR VGND sky130_ef_sc_hd__decap_12
XFILLER_42_419 VGND VGND VPWR VPWR sky130_fd_sc_hd__fill_1
XFILLER_22_121 VGND VGND VPWR VPWR sky130_fd_sc_hd__fill_1
XFILLER_50_463 VPWR VGND VPWR VGND sky130_ef_sc_hd__decap_12
X_3989_ _3989_/A _3989_/B VGND VGND VPWR VPWR _3989_/Y sky130_fd_sc_hd__xnor2_1
XFILLER_10_338 VGND VGND VPWR VPWR sky130_fd_sc_hd__decap_4
XFILLER_104_421 VPWR VGND VPWR VGND sky130_ef_sc_hd__decap_12
XFILLER_77_69 VGND VGND VPWR VPWR sky130_fd_sc_hd__fill_2
XFILLER_93_57 VPWR VGND VPWR VGND sky130_ef_sc_hd__decap_12
XFILLER_14_633 VGND VGND VPWR VPWR sky130_fd_sc_hd__decap_4
XFILLER_53_290 VPWR VGND VPWR VGND sky130_ef_sc_hd__decap_12
XFILLER_60_249 VGND VGND VPWR VPWR sky130_fd_sc_hd__decap_3
XTAP_TAPCELL_ROW_11_355 VGND VPWR sky130_fd_sc_hd__tapvpwrvgnd_1
XFILLER_9_169 VGND VGND VPWR VPWR sky130_fd_sc_hd__decap_4
XFILLER_42_83 VGND VGND VPWR VPWR sky130_fd_sc_hd__fill_1
XFILLER_42_94 VGND VGND VPWR VPWR sky130_fd_sc_hd__decap_4
XTAP_TAPCELL_ROW_97_1298 VGND VPWR sky130_fd_sc_hd__tapvpwrvgnd_1
XFILLER_107_281 VPWR VGND VPWR VGND sky130_ef_sc_hd__decap_12
XFILLER_96_625 VPWR VGND VPWR VGND sky130_ef_sc_hd__decap_12
XFILLER_95_113 VPWR VGND VPWR VGND sky130_ef_sc_hd__decap_12
XFILLER_3_55 VGND VGND VPWR VPWR sky130_fd_sc_hd__fill_1
XFILLER_83_308 VPWR VGND VPWR VGND sky130_ef_sc_hd__decap_12
X_3010_ _2965_/Y _3009_/X _3008_/Y _2987_/B VGND VGND VPWR VPWR _3010_/X sky130_fd_sc_hd__o211a_1
XFILLER_64_533 VPWR VGND VPWR VGND sky130_ef_sc_hd__decap_12
XFILLER_36_235 VPWR VGND VPWR VGND sky130_ef_sc_hd__decap_12
XTAP_TAPCELL_ROW_19_444 VGND VPWR sky130_fd_sc_hd__tapvpwrvgnd_1
XTAP_TAPCELL_ROW_47_753 VGND VPWR sky130_fd_sc_hd__tapvpwrvgnd_1
XTAP_TAPCELL_ROW_106_1394 VGND VPWR sky130_fd_sc_hd__tapvpwrvgnd_1
X_3912_ _4764_/Q _3913_/B VGND VGND VPWR VPWR _3938_/B sky130_fd_sc_hd__nor2_1
X_3843_ _3843_/A _3843_/B _3843_/C _3843_/D VGND VGND VPWR VPWR _3843_/X sky130_fd_sc_hd__or4_1
XFILLER_32_485 VGND VGND VPWR VPWR sky130_fd_sc_hd__fill_2
X_3774_ _3774_/A _3774_/B VGND VGND VPWR VPWR _3775_/B sky130_fd_sc_hd__nor2_1
XFILLER_8_180 VGND VGND VPWR VPWR sky130_fd_sc_hd__decap_4
X_2725_ _4528_/Q _2679_/B _2700_/B _2698_/X VGND VGND VPWR VPWR _2725_/Y sky130_fd_sc_hd__a31oi_1
X_2656_ _2658_/B _2658_/C _3382_/A VGND VGND VPWR VPWR _2660_/A sky130_fd_sc_hd__a21o_1
Xclkbuf_leaf_8_clk clkload2/A VGND VGND VPWR VPWR _4752_/CLK sky130_fd_sc_hd__clkbuf_8
XFILLER_99_441 VGND VGND VPWR VPWR sky130_fd_sc_hd__decap_6
XTAP_TAPCELL_ROW_74_1051 VGND VPWR sky130_fd_sc_hd__tapvpwrvgnd_1
X_2587_ _4491_/Q _2587_/B VGND VGND VPWR VPWR _2588_/B sky130_fd_sc_hd__xor2_2
Xfanout104 _4717_/Q VGND VGND VPWR VPWR _2431_/A sky130_fd_sc_hd__buf_2
XFILLER_99_485 VPWR VGND VPWR VGND sky130_ef_sc_hd__decap_12
Xfanout137 fanout145/X VGND VGND VPWR VPWR fanout137/X sky130_fd_sc_hd__clkbuf_2
X_4326_ _4738_/Q _4331_/A2 _3303_/A _4331_/B2 VGND VGND VPWR VPWR _4738_/D sky130_fd_sc_hd__a22o_1
Xfanout126 fanout128/X VGND VGND VPWR VPWR fanout126/X sky130_fd_sc_hd__clkbuf_2
Xfanout115 _4436_/Q VGND VGND VPWR VPWR _4319_/S0 sky130_fd_sc_hd__buf_4
XFILLER_59_305 VGND VGND VPWR VPWR sky130_fd_sc_hd__fill_2
Xfanout159 fanout166/X VGND VGND VPWR VPWR fanout159/X sky130_fd_sc_hd__buf_2
Xfanout148 fanout151/X VGND VGND VPWR VPWR fanout148/X sky130_fd_sc_hd__clkbuf_4
X_4257_ _4714_/Q _4259_/B VGND VGND VPWR VPWR _4265_/C sky130_fd_sc_hd__and2_1
X_3208_ _3188_/X _3191_/B _3187_/X VGND VGND VPWR VPWR _3209_/B sky130_fd_sc_hd__a21o_1
X_4188_ _4694_/Q _4187_/B _4213_/A1 VGND VGND VPWR VPWR _4188_/Y sky130_fd_sc_hd__o21ai_1
XFILLER_47_39 VPWR VGND VPWR VGND sky130_ef_sc_hd__decap_12
X_3139_ _4543_/Q _4552_/Q VGND VGND VPWR VPWR _3141_/B sky130_fd_sc_hd__or2_1
XFILLER_67_393 VGND VGND VPWR VPWR sky130_fd_sc_hd__decap_8
XFILLER_27_213 VGND VGND VPWR VPWR sky130_fd_sc_hd__decap_8
XFILLER_70_525 VGND VGND VPWR VPWR sky130_fd_sc_hd__decap_6
XFILLER_63_27 VPWR VGND VPWR VGND sky130_ef_sc_hd__decap_12
XFILLER_70_569 VPWR VGND VPWR VGND sky130_ef_sc_hd__decap_12
XFILLER_11_614 VGND VGND VPWR VPWR sky130_fd_sc_hd__fill_2
XFILLER_11_636 VGND VGND VPWR VPWR sky130_fd_sc_hd__fill_1
XFILLER_11_625 VGND VGND VPWR VPWR sky130_fd_sc_hd__decap_3
XFILLER_10_113 VGND VGND VPWR VPWR sky130_fd_sc_hd__fill_1
XFILLER_10_135 VGND VGND VPWR VPWR sky130_fd_sc_hd__decap_4
XFILLER_7_629 VGND VGND VPWR VPWR sky130_fd_sc_hd__decap_8
XFILLER_12_53 VPWR VGND VPWR VGND sky130_ef_sc_hd__decap_12
XFILLER_6_139 VGND VGND VPWR VPWR sky130_fd_sc_hd__fill_1
Xhold180 _4608_/Q VGND VGND VPWR VPWR hold180/X sky130_fd_sc_hd__dlygate4sd3_1
XFILLER_5_3 VPWR VGND VPWR VGND sky130_ef_sc_hd__decap_12
XFILLER_104_251 VGND VGND VPWR VPWR sky130_fd_sc_hd__fill_1
XFILLER_78_625 VPWR VGND VPWR VGND sky130_ef_sc_hd__decap_12
Xhold191 _4569_/Q VGND VGND VPWR VPWR hold191/X sky130_fd_sc_hd__dlygate4sd3_1
XFILLER_93_617 VPWR VGND VPWR VGND sky130_ef_sc_hd__decap_12
XFILLER_18_224 VGND VGND VPWR VPWR sky130_fd_sc_hd__decap_8
XFILLER_58_382 VPWR VGND VPWR VGND sky130_ef_sc_hd__decap_12
XFILLER_73_363 VGND VGND VPWR VPWR sky130_fd_sc_hd__decap_8
XTAP_TAPCELL_ROW_16_403 VGND VPWR sky130_fd_sc_hd__tapvpwrvgnd_1
XTAP_TAPCELL_ROW_44_712 VGND VPWR sky130_fd_sc_hd__tapvpwrvgnd_1
XTAP_TAPCELL_ROW_99_1316 VGND VPWR sky130_fd_sc_hd__tapvpwrvgnd_1
XTAP_TAPCELL_ROW_24_491 VGND VPWR sky130_fd_sc_hd__tapvpwrvgnd_1
X_3490_ _3448_/A _3448_/B _3464_/X _3465_/B _4531_/Q VGND VGND VPWR VPWR _3491_/C
+ sky130_fd_sc_hd__a32o_1
X_2510_ _2526_/A1 _2508_/Y _2509_/Y _2526_/B1 hold60/X VGND VGND VPWR VPWR _4464_/D
+ sky130_fd_sc_hd__a32o_1
X_2441_ _2445_/B VGND VGND VPWR VPWR _2441_/Y sky130_fd_sc_hd__inv_2
XFILLER_5_150 VGND VGND VPWR VPWR sky130_fd_sc_hd__fill_1
XFILLER_38_3 VPWR VGND VPWR VGND sky130_ef_sc_hd__decap_12
X_2372_ hold22/X _2379_/A2 _2379_/B1 _4537_/Q VGND VGND VPWR VPWR _4387_/D sky130_fd_sc_hd__a22o_1
XFILLER_96_433 VPWR VGND VPWR VGND sky130_ef_sc_hd__decap_12
X_4111_ hold109/X _4028_/X _4112_/S VGND VGND VPWR VPWR _4643_/D sky130_fd_sc_hd__mux2_1
XFILLER_96_477 VPWR VGND VPWR VGND sky130_ef_sc_hd__decap_12
X_4042_ _4132_/A1 hold185/X _4049_/S VGND VGND VPWR VPWR _4581_/D sky130_fd_sc_hd__mux2_1
XFILLER_49_393 VGND VGND VPWR VPWR sky130_fd_sc_hd__fill_2
XFILLER_52_536 VPWR VGND VPWR VGND sky130_ef_sc_hd__decap_12
X_3826_ _3826_/A _3826_/B VGND VGND VPWR VPWR _3833_/A sky130_fd_sc_hd__xnor2_1
X_3757_ _4642_/Q _4578_/Q _4674_/Q _4610_/Q _3915_/S0 _3915_/S1 VGND VGND VPWR VPWR
+ _3759_/B sky130_fd_sc_hd__mux4_1
X_2708_ _4497_/Q _3277_/B2 _3495_/A _2708_/B2 VGND VGND VPWR VPWR _4497_/D sky130_fd_sc_hd__a22o_1
X_3688_ _4538_/Q _3642_/B _3662_/B _4539_/Q VGND VGND VPWR VPWR _3688_/X sky130_fd_sc_hd__a22o_1
X_2639_ _2639_/A _2639_/B VGND VGND VPWR VPWR _2640_/B sky130_fd_sc_hd__xor2_1
XFILLER_58_27 VGND VGND VPWR VPWR sky130_fd_sc_hd__fill_1
XFILLER_99_293 VPWR VGND VPWR VGND sky130_ef_sc_hd__decap_12
XFILLER_87_422 VPWR VGND VPWR VGND sky130_ef_sc_hd__decap_12
X_4309_ uo_out[5] _4308_/Y _4323_/S VGND VGND VPWR VPWR _4724_/D sky130_fd_sc_hd__mux2_1
XFILLER_75_617 VPWR VGND VPWR VGND sky130_ef_sc_hd__decap_12
XFILLER_74_15 VPWR VGND VPWR VGND sky130_ef_sc_hd__decap_12
XFILLER_28_533 VPWR VGND VPWR VGND sky130_ef_sc_hd__decap_12
XFILLER_70_322 VGND VGND VPWR VPWR sky130_fd_sc_hd__fill_1
XFILLER_43_547 VGND VGND VPWR VPWR sky130_fd_sc_hd__fill_1
XFILLER_11_400 VGND VGND VPWR VPWR sky130_fd_sc_hd__decap_3
XFILLER_23_260 VGND VGND VPWR VPWR sky130_fd_sc_hd__decap_8
XTAP_TAPCELL_ROW_21_461 VGND VPWR sky130_fd_sc_hd__tapvpwrvgnd_1
XTAP_TAPCELL_ROW_94_1268 VGND VPWR sky130_fd_sc_hd__tapvpwrvgnd_1
XFILLER_2_197 VPWR VGND VPWR VGND sky130_ef_sc_hd__decap_12
XFILLER_78_477 VPWR VGND VPWR VGND sky130_ef_sc_hd__decap_12
XFILLER_78_455 VPWR VGND VPWR VGND sky130_ef_sc_hd__decap_12
XFILLER_93_447 VGND VGND VPWR VPWR sky130_fd_sc_hd__fill_1
XFILLER_19_511 VGND VGND VPWR VPWR sky130_fd_sc_hd__fill_1
XFILLER_81_609 VGND VGND VPWR VPWR sky130_fd_sc_hd__decap_6
XFILLER_0_12 VGND VGND VPWR VPWR sky130_fd_sc_hd__decap_4
XTAP_TAPCELL_ROW_29_550 VGND VPWR sky130_fd_sc_hd__tapvpwrvgnd_1
XFILLER_34_514 VGND VGND VPWR VPWR sky130_fd_sc_hd__decap_8
XFILLER_46_363 VGND VGND VPWR VPWR sky130_fd_sc_hd__fill_1
XFILLER_61_377 VGND VGND VPWR VPWR sky130_fd_sc_hd__decap_4
X_2990_ _4537_/Q _3836_/A VGND VGND VPWR VPWR _2992_/B sky130_fd_sc_hd__or2_1
XTAP_TAPCELL_ROW_103_1364 VGND VPWR sky130_fd_sc_hd__tapvpwrvgnd_1
X_4660_ _4661_/CLK _4660_/D fanout123/X VGND VGND VPWR VPWR _4660_/Q sky130_fd_sc_hd__dfrtp_1
X_3611_ _3583_/A _3588_/X _3610_/Y VGND VGND VPWR VPWR _3611_/Y sky130_fd_sc_hd__a21oi_1
X_4591_ _4656_/CLK _4591_/D fanout120/X VGND VGND VPWR VPWR _4591_/Q sky130_fd_sc_hd__dfrtp_1
XFILLER_6_470 VGND VGND VPWR VPWR sky130_fd_sc_hd__decap_6
X_3542_ _3648_/A _3542_/B VGND VGND VPWR VPWR _3629_/B sky130_fd_sc_hd__xnor2_1
X_3473_ hold71/A hold68/A _4663_/Q _4599_/Q _3599_/S0 _3519_/S VGND VGND VPWR VPWR
+ _3475_/B sky130_fd_sc_hd__mux4_1
XTAP_TAPCELL_ROW_71_1010 VGND VPWR sky130_fd_sc_hd__tapvpwrvgnd_1
X_2424_ _2427_/A _2427_/C _2422_/Y VGND VGND VPWR VPWR _4436_/D sky130_fd_sc_hd__o21ba_1
X_2355_ _2354_/A _2423_/B _2256_/B VGND VGND VPWR VPWR _2355_/X sky130_fd_sc_hd__a21o_1
XFILLER_57_617 VPWR VGND VPWR VGND sky130_ef_sc_hd__decap_12
X_2286_ _2281_/X _2282_/X _2316_/B _2280_/X _2285_/Y VGND VGND VPWR VPWR _2286_/X
+ sky130_fd_sc_hd__a221o_1
XFILLER_84_469 VGND VGND VPWR VPWR sky130_fd_sc_hd__decap_6
X_4025_ _4095_/B _4016_/B _4136_/A1 _4016_/Y hold191/X VGND VGND VPWR VPWR _4569_/D
+ sky130_fd_sc_hd__a32o_1
XFILLER_37_330 VGND VGND VPWR VPWR sky130_fd_sc_hd__decap_6
XFILLER_25_503 VGND VGND VPWR VPWR sky130_fd_sc_hd__fill_1
XFILLER_44_29 VPWR VGND VPWR VGND sky130_ef_sc_hd__decap_12
XFILLER_52_377 VPWR VGND VPWR VGND sky130_ef_sc_hd__decap_12
X_3809_ _3809_/A _3809_/B VGND VGND VPWR VPWR _3810_/B sky130_fd_sc_hd__xnor2_2
XFILLER_106_357 VGND VGND VPWR VPWR sky130_fd_sc_hd__decap_6
XFILLER_69_15 VPWR VGND VPWR VGND sky130_ef_sc_hd__decap_12
XFILLER_0_635 VGND VGND VPWR VPWR sky130_fd_sc_hd__fill_2
XFILLER_85_69 VGND VGND VPWR VPWR sky130_fd_sc_hd__fill_1
XFILLER_63_609 VGND VGND VPWR VPWR sky130_fd_sc_hd__decap_6
XFILLER_18_41 VPWR VGND VPWR VGND sky130_ef_sc_hd__decap_12
XFILLER_90_406 VPWR VGND VPWR VGND sky130_ef_sc_hd__decap_12
XFILLER_18_85 VPWR VGND VPWR VGND sky130_ef_sc_hd__decap_12
XFILLER_28_363 VGND VGND VPWR VPWR sky130_fd_sc_hd__fill_1
XTAP_TAPCELL_ROW_26_520 VGND VPWR sky130_fd_sc_hd__tapvpwrvgnd_1
XFILLER_70_163 VGND VGND VPWR VPWR sky130_fd_sc_hd__fill_1
XFILLER_70_141 VGND VGND VPWR VPWR sky130_fd_sc_hd__decap_8
XFILLER_31_517 VPWR VGND VPWR VGND sky130_ef_sc_hd__decap_12
XFILLER_70_185 VGND VGND VPWR VPWR sky130_fd_sc_hd__fill_2
XFILLER_50_83 VGND VGND VPWR VPWR sky130_fd_sc_hd__fill_1
XFILLER_39_617 VGND VGND VPWR VPWR sky130_fd_sc_hd__decap_3
XFILLER_39_628 VGND VGND VPWR VPWR sky130_fd_sc_hd__fill_1
XFILLER_19_341 VGND VGND VPWR VPWR sky130_fd_sc_hd__fill_1
XFILLER_38_138 VGND VGND VPWR VPWR sky130_fd_sc_hd__fill_2
XFILLER_34_344 VGND VGND VPWR VPWR sky130_fd_sc_hd__decap_6
XFILLER_34_377 VGND VGND VPWR VPWR sky130_fd_sc_hd__fill_2
X_2973_ _2973_/A _2973_/B VGND VGND VPWR VPWR _2974_/B sky130_fd_sc_hd__nor2_1
XPHY_EDGE_ROW_101_Left_209 VGND VGND VPWR VPWR sky130_fd_sc_hd__decap_3
X_4712_ _4712_/CLK _4712_/D fanout172/X VGND VGND VPWR VPWR _4712_/Q sky130_fd_sc_hd__dfrtp_2
XTAP_TAPCELL_ROW_32_589 VGND VPWR sky130_fd_sc_hd__tapvpwrvgnd_1
XTAP_TAPCELL_ROW_60_887 VGND VPWR sky130_fd_sc_hd__tapvpwrvgnd_1
X_4643_ _4756_/CLK _4643_/D fanout137/X VGND VGND VPWR VPWR _4643_/Q sky130_fd_sc_hd__dfrtp_1
X_4574_ _4752_/CLK _4574_/D fanout136/X VGND VGND VPWR VPWR _4574_/Q sky130_fd_sc_hd__dfrtp_1
X_3525_ _3525_/A _3525_/B _3525_/C VGND VGND VPWR VPWR _3526_/C sky130_fd_sc_hd__nand3_1
XFILLER_103_305 VPWR VGND VPWR VGND sky130_ef_sc_hd__decap_12
XFILLER_89_517 VPWR VGND VPWR VGND sky130_ef_sc_hd__decap_12
XFILLER_103_349 VPWR VGND VPWR VGND sky130_ef_sc_hd__decap_12
X_3456_ _4745_/Q _3456_/B VGND VGND VPWR VPWR _3459_/A sky130_fd_sc_hd__xor2_1
XFILLER_97_561 VPWR VGND VPWR VGND sky130_ef_sc_hd__decap_12
X_3387_ _4742_/Q _3387_/B VGND VGND VPWR VPWR _3388_/B sky130_fd_sc_hd__nor2_1
X_2407_ hold144/X _2407_/A2 _2407_/B1 _4508_/Q VGND VGND VPWR VPWR _2407_/X sky130_fd_sc_hd__a22o_1
X_2338_ _4718_/Q _4727_/Q VGND VGND VPWR VPWR _4095_/A sky130_fd_sc_hd__nand2_8
X_2269_ _2271_/B _2269_/B _2269_/C VGND VGND VPWR VPWR _2319_/B sky130_fd_sc_hd__or3_1
XTAP_TAPCELL_ROW_68_976 VGND VPWR sky130_fd_sc_hd__tapvpwrvgnd_1
X_4008_ _4728_/Q _4030_/B VGND VGND VPWR VPWR _4008_/X sky130_fd_sc_hd__and2_2
XFILLER_37_160 VGND VGND VPWR VPWR sky130_fd_sc_hd__decap_8
XFILLER_55_39 VPWR VGND VPWR VGND sky130_ef_sc_hd__decap_12
XFILLER_80_450 VPWR VGND VPWR VGND sky130_ef_sc_hd__decap_12
XFILLER_25_344 VGND VGND VPWR VPWR sky130_fd_sc_hd__decap_3
XFILLER_25_355 VGND VGND VPWR VPWR sky130_fd_sc_hd__fill_1
XFILLER_52_152 VGND VGND VPWR VPWR sky130_fd_sc_hd__decap_4
XTAP_TAPCELL_ROW_80_1109 VGND VPWR sky130_fd_sc_hd__tapvpwrvgnd_1
XFILLER_71_27 VPWR VGND VPWR VGND sky130_ef_sc_hd__decap_12
XFILLER_40_303 VGND VGND VPWR VPWR sky130_fd_sc_hd__decap_4
XFILLER_40_314 VGND VGND VPWR VPWR sky130_fd_sc_hd__decap_3
XFILLER_40_325 VGND VGND VPWR VPWR sky130_fd_sc_hd__decap_4
XFILLER_52_185 VGND VGND VPWR VPWR sky130_fd_sc_hd__fill_2
XFILLER_21_561 VPWR VGND VPWR VGND sky130_ef_sc_hd__decap_12
XFILLER_106_121 VPWR VGND VPWR VGND sky130_ef_sc_hd__decap_12
XFILLER_105_3 VPWR VGND VPWR VGND sky130_ef_sc_hd__decap_12
XFILLER_106_165 VPWR VGND VPWR VGND sky130_ef_sc_hd__decap_12
XTAP_TAPCELL_ROW_91_1238 VGND VPWR sky130_fd_sc_hd__tapvpwrvgnd_1
XFILLER_20_53 VPWR VGND VPWR VGND sky130_ef_sc_hd__decap_12
XFILLER_0_432 VPWR VGND VPWR VGND sky130_ef_sc_hd__decap_12
XFILLER_75_200 VGND VGND VPWR VPWR sky130_fd_sc_hd__decap_8
XFILLER_29_51 VGND VGND VPWR VPWR sky130_fd_sc_hd__decap_4
Xhold40 hold40/A VGND VGND VPWR VPWR hold40/X sky130_fd_sc_hd__dlygate4sd3_1
Xhold51 hold51/A VGND VGND VPWR VPWR hold51/X sky130_fd_sc_hd__dlygate4sd3_1
XFILLER_29_95 VGND VGND VPWR VPWR sky130_fd_sc_hd__decap_6
Xhold73 hold73/A VGND VGND VPWR VPWR hold73/X sky130_fd_sc_hd__dlygate4sd3_1
Xhold62 hold62/A VGND VGND VPWR VPWR hold62/X sky130_fd_sc_hd__dlygate4sd3_1
Xhold95 hold95/A VGND VGND VPWR VPWR hold95/X sky130_fd_sc_hd__dlygate4sd3_1
XFILLER_63_406 VGND VGND VPWR VPWR sky130_fd_sc_hd__fill_1
XTAP_TAPCELL_ROW_3_270 VGND VPWR sky130_fd_sc_hd__tapvpwrvgnd_1
Xhold84 hold84/A VGND VGND VPWR VPWR hold84/X sky130_fd_sc_hd__dlygate4sd3_1
XFILLER_75_299 VGND VGND VPWR VPWR sky130_fd_sc_hd__decap_8
XFILLER_44_631 VGND VGND VPWR VPWR sky130_fd_sc_hd__decap_6
XFILLER_16_399 VPWR VGND VPWR VGND sky130_ef_sc_hd__decap_12
XTAP_TAPCELL_ROW_100_1334 VGND VPWR sky130_fd_sc_hd__tapvpwrvgnd_1
XANTENNA_4 _4734_/Q VGND VGND VPWR VPWR sky130_fd_sc_hd__diode_2
XFILLER_6_77 VGND VGND VPWR VPWR sky130_fd_sc_hd__decap_6
X_3310_ _3310_/A _3310_/B VGND VGND VPWR VPWR _3311_/B sky130_fd_sc_hd__xnor2_1
XFILLER_3_281 VPWR VGND VPWR VGND sky130_ef_sc_hd__decap_12
X_4290_ _4318_/A _4290_/B VGND VGND VPWR VPWR _4290_/Y sky130_fd_sc_hd__nor2_1
X_3241_ _3242_/B _4520_/Q VGND VGND VPWR VPWR _3241_/X sky130_fd_sc_hd__and2b_1
XFILLER_79_561 VPWR VGND VPWR VGND sky130_ef_sc_hd__decap_12
X_3172_ _3967_/A VGND VGND VPWR VPWR _3882_/A sky130_fd_sc_hd__inv_2
XFILLER_20_3 VPWR VGND VPWR VGND sky130_ef_sc_hd__decap_12
XFILLER_94_531 VGND VGND VPWR VPWR sky130_fd_sc_hd__fill_1
XFILLER_66_222 VGND VGND VPWR VPWR sky130_fd_sc_hd__fill_2
XFILLER_27_609 VGND VGND VPWR VPWR sky130_fd_sc_hd__decap_4
XFILLER_39_469 VGND VGND VPWR VPWR sky130_fd_sc_hd__decap_3
XFILLER_54_406 VPWR VGND VPWR VGND sky130_ef_sc_hd__decap_12
XFILLER_81_225 VGND VGND VPWR VPWR sky130_fd_sc_hd__decap_6
XTAP_TAPCELL_ROW_65_946 VGND VPWR sky130_fd_sc_hd__tapvpwrvgnd_1
XTAP_TAPCELL_ROW_37_637 VGND VPWR sky130_fd_sc_hd__tapvpwrvgnd_1
XFILLER_34_141 VGND VGND VPWR VPWR sky130_fd_sc_hd__decap_6
X_2956_ _3028_/B _2956_/B VGND VGND VPWR VPWR _3650_/A sky130_fd_sc_hd__xnor2_4
X_2887_ _4533_/Q _4542_/Q VGND VGND VPWR VPWR _2889_/B sky130_fd_sc_hd__or2_1
X_4626_ _4656_/CLK _4626_/D fanout121/X VGND VGND VPWR VPWR _4626_/Q sky130_fd_sc_hd__dfrtp_1
XTAP_TAPCELL_ROW_77_1082 VGND VPWR sky130_fd_sc_hd__tapvpwrvgnd_1
XTAP_TAPCELL_ROW_9_329 VGND VPWR sky130_fd_sc_hd__tapvpwrvgnd_1
X_4557_ _4656_/CLK _4557_/D fanout120/X VGND VGND VPWR VPWR _4557_/Q sky130_fd_sc_hd__dfrtp_1
XFILLER_104_625 VPWR VGND VPWR VGND sky130_ef_sc_hd__decap_12
XFILLER_103_113 VPWR VGND VPWR VGND sky130_ef_sc_hd__decap_12
X_4488_ _4532_/CLK _4488_/D fanout151/X VGND VGND VPWR VPWR _4488_/Q sky130_fd_sc_hd__dfrtp_1
X_3508_ _3508_/A _3508_/B VGND VGND VPWR VPWR _3510_/B sky130_fd_sc_hd__xnor2_1
X_3439_ _3440_/A _3440_/B VGND VGND VPWR VPWR _3441_/A sky130_fd_sc_hd__nor2_1
XFILLER_66_27 VGND VGND VPWR VPWR sky130_fd_sc_hd__fill_1
XFILLER_57_211 VGND VGND VPWR VPWR sky130_fd_sc_hd__fill_1
XFILLER_97_391 VGND VGND VPWR VPWR sky130_fd_sc_hd__fill_1
XFILLER_85_553 VGND VGND VPWR VPWR sky130_fd_sc_hd__decap_6
XFILLER_57_244 VGND VGND VPWR VPWR sky130_fd_sc_hd__decap_8
XFILLER_17_108 VGND VGND VPWR VPWR sky130_fd_sc_hd__decap_4
XFILLER_85_597 VPWR VGND VPWR VGND sky130_ef_sc_hd__decap_12
XFILLER_82_15 VPWR VGND VPWR VGND sky130_ef_sc_hd__decap_12
XFILLER_25_130 VGND VGND VPWR VPWR sky130_fd_sc_hd__fill_1
XFILLER_80_280 VGND VGND VPWR VPWR sky130_fd_sc_hd__fill_2
XFILLER_13_358 VGND VGND VPWR VPWR sky130_fd_sc_hd__decap_6
XFILLER_40_177 VPWR VGND VPWR VGND sky130_ef_sc_hd__decap_12
XFILLER_95_317 VGND VGND VPWR VPWR sky130_fd_sc_hd__fill_1
XFILLER_88_391 VGND VGND VPWR VPWR sky130_fd_sc_hd__fill_1
XFILLER_88_380 VGND VGND VPWR VPWR sky130_fd_sc_hd__fill_2
XFILLER_76_531 VGND VGND VPWR VPWR sky130_fd_sc_hd__fill_1
XFILLER_48_266 VPWR VGND VPWR VGND sky130_ef_sc_hd__decap_12
XFILLER_63_225 VGND VGND VPWR VPWR sky130_fd_sc_hd__fill_2
XTAP_TAPCELL_ROW_62_916 VGND VPWR sky130_fd_sc_hd__tapvpwrvgnd_1
XFILLER_16_141 VGND VGND VPWR VPWR sky130_fd_sc_hd__fill_1
XTAP_TAPCELL_ROW_34_607 VGND VPWR sky130_fd_sc_hd__tapvpwrvgnd_1
XFILLER_44_472 VGND VGND VPWR VPWR sky130_fd_sc_hd__decap_4
X_3790_ _3791_/A _3791_/B VGND VGND VPWR VPWR _3790_/Y sky130_fd_sc_hd__nor2_1
XFILLER_31_177 VGND VGND VPWR VPWR sky130_fd_sc_hd__fill_2
X_2810_ _4746_/Q _2810_/B _2810_/C VGND VGND VPWR VPWR _2810_/Y sky130_fd_sc_hd__nand3_1
XTAP_TAPCELL_ROW_14_386 VGND VPWR sky130_fd_sc_hd__tapvpwrvgnd_1
X_2741_ _4531_/Q _2741_/B _2741_/C VGND VGND VPWR VPWR _2743_/A sky130_fd_sc_hd__and3_1
XTAP_TAPCELL_ROW_42_695 VGND VPWR sky130_fd_sc_hd__tapvpwrvgnd_1
XFILLER_68_3 VPWR VGND VPWR VGND sky130_ef_sc_hd__decap_12
X_2672_ _4742_/Q _2672_/B VGND VGND VPWR VPWR _2710_/A sky130_fd_sc_hd__xnor2_1
X_4411_ _4504_/CLK hold40/X fanout130/X VGND VGND VPWR VPWR hold39/A sky130_fd_sc_hd__dfrtp_1
X_4342_ _3468_/A _3720_/A _4345_/A2 hold299/X VGND VGND VPWR VPWR _4754_/D sky130_fd_sc_hd__a2bb2o_1
XFILLER_98_133 VGND VGND VPWR VPWR sky130_fd_sc_hd__decap_6
X_4273_ _4482_/Q _4273_/B VGND VGND VPWR VPWR _4273_/Y sky130_fd_sc_hd__xnor2_1
XFILLER_101_617 VPWR VGND VPWR VGND sky130_ef_sc_hd__decap_12
XFILLER_98_177 VPWR VGND VPWR VGND sky130_ef_sc_hd__decap_12
X_3224_ _4519_/Q _3224_/B VGND VGND VPWR VPWR _3226_/A sky130_fd_sc_hd__xnor2_2
XFILLER_86_317 VGND VGND VPWR VPWR sky130_fd_sc_hd__fill_2
.ends
